* AIPE behavioural synchronous buck: switching_360
Vin src 0 DC 360
Lin src inf 1e-05
Rin inf in 0.08
Cin in cinx 5.4e-05
Rcin cinx cins 0.002275
Vcin cins 0 0
Vhs in hs_a 0
Shs hs_a sw ghs 0 SWHS
Dhs sw hs_a DBODY
Sls sw ls_a gls 0 SWLS
Dls dls_a sw DBODY
Vdls ls_a dls_a 0
Vls ls_a 0 0
L1 sw lx 0.000348647709396
Rdcr lx out 0.0220054349141
Cout out cx 0.00018
Resr cx cs 0.00215
Vcout cs 0 0
Vld out ld 0
Rload ld 0 8
Bduty duty 0 V = 0.562333333333*min(1, time/0.002)
Vghs ghs 0 PWL(0 0 1.9995e-05 0 2.0005e-05 1 2.01074666667e-05 1 2.01174666667e-05 0 3.9995e-05 0 4.0005e-05 1 4.02199333333e-05 1 4.02299333333e-05 0 5.9995e-05 0 6.0005e-05 1 6.03324e-05 1 6.03424e-05 0 7.9995e-05 0 8.0005e-05 1 8.04448666667e-05 1
+ 8.04548666667e-05 0 9.9995e-05 0 0.000100005 1 0.000100557333333 1 0.000100567333333 0 0.000119995 0 0.000120005 1 0.0001206698 1 0.0001206798 0 0.000139995 0 0.000140005 1 0.000140782266667 1 0.000140792266667 0 0.000159995 0 0.000160005 1 0.000160894733333 1
+ 0.000160904733333 0 0.000179995 0 0.000180005 1 0.0001810072 1 0.0001810172 0 0.000199995 0 0.000200005 1 0.000201119666667 1 0.000201129666667 0 0.000219995 0 0.000220005 1 0.000221232133333 1 0.000221242133333 0 0.000239995 0 0.000240005 1 0.0002413446 1
+ 0.0002413546 0 0.000259995 0 0.000260005 1 0.000261457066667 1 0.000261467066667 0 0.000279995 0 0.000280005 1 0.000281569533333 1 0.000281579533333 0 0.000299995 0 0.000300005 1 0.000301682 1 0.000301692 0 0.000319995 0 0.000320005 1 0.000321794466667 1
+ 0.000321804466667 0 0.000339995 0 0.000340005 1 0.000341906933333 1 0.000341916933333 0 0.000359995 0 0.000360005 1 0.0003620194 1 0.0003620294 0 0.000379995 0 0.000380005 1 0.000382131866667 1 0.000382141866667 0 0.000399995 0 0.000400005 1 0.000402244333333 1
+ 0.000402254333333 0 0.000419995 0 0.000420005 1 0.0004223568 1 0.0004223668 0 0.000439995 0 0.000440005 1 0.000442469266667 1 0.000442479266667 0 0.000459995 0 0.000460005 1 0.000462581733333 1 0.000462591733333 0 0.000479995 0 0.000480005 1 0.0004826942 1
+ 0.0004827042 0 0.000499995 0 0.000500005 1 0.000502806666667 1 0.000502816666667 0 0.000519995 0 0.000520005 1 0.000522919133333 1 0.000522929133333 0 0.000539995 0 0.000540005 1 0.0005430316 1 0.0005430416 0 0.000559995 0 0.000560005 1 0.000563144066667 1
+ 0.000563154066667 0 0.000579995 0 0.000580005 1 0.000583256533333 1 0.000583266533333 0 0.000599995 0 0.000600005 1 0.000603369 1 0.000603379 0 0.000619995 0 0.000620005 1 0.000623481466667 1 0.000623491466667 0 0.000639995 0 0.000640005 1 0.000643593933333 1
+ 0.000643603933333 0 0.000659995 0 0.000660005 1 0.0006637064 1 0.0006637164 0 0.000679995 0 0.000680005 1 0.000683818866667 1 0.000683828866667 0 0.000699995 0 0.000700005 1 0.000703931333333 1 0.000703941333333 0 0.000719995 0 0.000720005 1 0.0007240438 1
+ 0.0007240538 0 0.000739995 0 0.000740005 1 0.000744156266667 1 0.000744166266667 0 0.000759995 0 0.000760005 1 0.000764268733333 1 0.000764278733333 0 0.000779995 0 0.000780005 1 0.0007843812 1 0.0007843912 0 0.000799995 0 0.000800005 1 0.000804493666667 1
+ 0.000804503666667 0 0.000819995 0 0.000820005 1 0.000824606133333 1 0.000824616133333 0 0.000839995 0 0.000840005 1 0.0008447186 1 0.0008447286 0 0.000859995 0 0.000860005 1 0.000864831066667 1 0.000864841066667 0 0.000879995 0 0.000880005 1 0.000884943533333 1
+ 0.000884953533333 0 0.000899995 0 0.000900005 1 0.000905056 1 0.000905066 0 0.000919995 0 0.000920005 1 0.000925168466667 1 0.000925178466667 0 0.000939995 0 0.000940005 1 0.000945280933333 1 0.000945290933333 0 0.000959995 0 0.000960005 1 0.0009653934 1
+ 0.0009654034 0 0.000979995 0 0.000980005 1 0.000985505866667 1 0.000985515866667 0 0.000999995 0 0.001000005 1 0.00100561833333 1 0.00100562833333 0 0.001019995 0 0.001020005 1 0.0010257308 1 0.0010257408 0 0.001039995 0 0.001040005 1 0.00104584326667 1
+ 0.00104585326667 0 0.001059995 0 0.001060005 1 0.00106595573333 1 0.00106596573333 0 0.001079995 0 0.001080005 1 0.0010860682 1 0.0010860782 0 0.001099995 0 0.001100005 1 0.00110618066667 1 0.00110619066667 0 0.001119995 0 0.001120005 1 0.00112629313333 1
+ 0.00112630313333 0 0.001139995 0 0.001140005 1 0.0011464056 1 0.0011464156 0 0.001159995 0 0.001160005 1 0.00116651806667 1 0.00116652806667 0 0.001179995 0 0.001180005 1 0.00118663053333 1 0.00118664053333 0 0.001199995 0 0.001200005 1 0.001206743 1
+ 0.001206753 0 0.001219995 0 0.001220005 1 0.00122685546667 1 0.00122686546667 0 0.001239995 0 0.001240005 1 0.00124696793333 1 0.00124697793333 0 0.001259995 0 0.001260005 1 0.0012670804 1 0.0012670904 0 0.001279995 0 0.001280005 1 0.00128719286667 1
+ 0.00128720286667 0 0.001299995 0 0.001300005 1 0.00130730533333 1 0.00130731533333 0 0.001319995 0 0.001320005 1 0.0013274178 1 0.0013274278 0 0.001339995 0 0.001340005 1 0.00134753026667 1 0.00134754026667 0 0.001359995 0 0.001360005 1 0.00136764273333 1
+ 0.00136765273333 0 0.001379995 0 0.001380005 1 0.0013877552 1 0.0013877652 0 0.001399995 0 0.001400005 1 0.00140786766667 1 0.00140787766667 0 0.001419995 0 0.001420005 1 0.00142798013333 1 0.00142799013333 0 0.001439995 0 0.001440005 1 0.0014480926 1
+ 0.0014481026 0 0.001459995 0 0.001460005 1 0.00146820506667 1 0.00146821506667 0 0.001479995 0 0.001480005 1 0.00148831753333 1 0.00148832753333 0 0.001499995 0 0.001500005 1 0.00150843 1 0.00150844 0 0.001519995 0 0.001520005 1 0.00152854246667 1
+ 0.00152855246667 0 0.001539995 0 0.001540005 1 0.00154865493333 1 0.00154866493333 0 0.001559995 0 0.001560005 1 0.0015687674 1 0.0015687774 0 0.001579995 0 0.001580005 1 0.00158887986667 1 0.00158888986667 0 0.001599995 0 0.001600005 1 0.00160899233333 1
+ 0.00160900233333 0 0.001619995 0 0.001620005 1 0.0016291048 1 0.0016291148 0 0.001639995 0 0.001640005 1 0.00164921726667 1 0.00164922726667 0 0.001659995 0 0.001660005 1 0.00166932973333 1 0.00166933973333 0 0.001679995 0 0.001680005 1 0.0016894422 1
+ 0.0016894522 0 0.001699995 0 0.001700005 1 0.00170955466667 1 0.00170956466667 0 0.001719995 0 0.001720005 1 0.00172966713333 1 0.00172967713333 0 0.001739995 0 0.001740005 1 0.0017497796 1 0.0017497896 0 0.001759995 0 0.001760005 1 0.00176989206667 1
+ 0.00176990206667 0 0.001779995 0 0.001780005 1 0.00179000453333 1 0.00179001453333 0 0.001799995 0 0.001800005 1 0.001810117 1 0.001810127 0 0.001819995 0 0.001820005 1 0.00183022946667 1 0.00183023946667 0 0.001839995 0 0.001840005 1 0.00185034193333 1
+ 0.00185035193333 0 0.001859995 0 0.001860005 1 0.0018704544 1 0.0018704644 0 0.001879995 0 0.001880005 1 0.00189056686667 1 0.00189057686667 0 0.001899995 0 0.001900005 1 0.00191067933333 1 0.00191068933333 0 0.001919995 0 0.001920005 1 0.0019307918 1
+ 0.0019308018 0 0.001939995 0 0.001940005 1 0.00195090426667 1 0.00195091426667 0 0.001959995 0 0.001960005 1 0.00197101673333 1 0.00197102673333 0 0.001979995 0 0.001980005 1 0.0019911292 1 0.0019911392 0 0.001999995 0 0.002000005 1 0.00201124166667 1
+ 0.00201125166667 0 0.002019995 0 0.002020005 1 0.00203124166667 1 0.00203125166667 0 0.002039995 0 0.002040005 1 0.00205124166667 1 0.00205125166667 0 0.002059995 0 0.002060005 1 0.00207124166667 1 0.00207125166667 0 0.002079995 0 0.002080005 1 0.00209124166667 1
+ 0.00209125166667 0 0.002099995 0 0.002100005 1 0.00211124166667 1 0.00211125166667 0 0.002119995 0 0.002120005 1 0.00213124166667 1 0.00213125166667 0 0.002139995 0 0.002140005 1 0.00215124166667 1 0.00215125166667 0 0.002159995 0 0.002160005 1 0.00217124166667 1
+ 0.00217125166667 0 0.002179995 0 0.002180005 1 0.00219124166667 1 0.00219125166667 0 0.002199995 0 0.002200005 1 0.00221124166667 1 0.00221125166667 0 0.002219995 0 0.002220005 1 0.00223124166667 1 0.00223125166667 0 0.002239995 0 0.002240005 1 0.00225124166667 1
+ 0.00225125166667 0 0.002259995 0 0.002260005 1 0.00227124166667 1 0.00227125166667 0 0.002279995 0 0.002280005 1 0.00229124166667 1 0.00229125166667 0 0.002299995 0 0.002300005 1 0.00231124166667 1 0.00231125166667 0 0.002319995 0 0.002320005 1 0.00233124166667 1
+ 0.00233125166667 0 0.002339995 0 0.002340005 1 0.00235124166667 1 0.00235125166667 0 0.002359995 0 0.002360005 1 0.00237124166667 1 0.00237125166667 0 0.002379995 0 0.002380005 1 0.00239124166667 1 0.00239125166667 0 0.002399995 0 0.002400005 1 0.00241124166667 1
+ 0.00241125166667 0 0.002419995 0 0.002420005 1 0.00243124166667 1 0.00243125166667 0 0.002439995 0 0.002440005 1 0.00245124166667 1 0.00245125166667 0 0.002459995 0 0.002460005 1 0.00247124166667 1 0.00247125166667 0 0.002479995 0 0.002480005 1 0.00249124166667 1
+ 0.00249125166667 0 0.002499995 0 0.002500005 1 0.00251124166667 1 0.00251125166667 0 0.002519995 0 0.002520005 1 0.00253124166667 1 0.00253125166667 0 0.002539995 0 0.002540005 1 0.00255124166667 1 0.00255125166667 0 0.002559995 0 0.002560005 1 0.00257124166667 1
+ 0.00257125166667 0 0.002579995 0 0.002580005 1 0.00259124166667 1 0.00259125166667 0 0.002599995 0 0.002600005 1 0.00261124166667 1 0.00261125166667 0 0.002619995 0 0.002620005 1 0.00263124166667 1 0.00263125166667 0 0.002639995 0 0.002640005 1 0.00265124166667 1
+ 0.00265125166667 0 0.002659995 0 0.002660005 1 0.00267124166667 1 0.00267125166667 0 0.002679995 0 0.002680005 1 0.00269124166667 1 0.00269125166667 0 0.002699995 0 0.002700005 1 0.00271124166667 1 0.00271125166667 0 0.002719995 0 0.002720005 1 0.00273124166667 1
+ 0.00273125166667 0 0.002739995 0 0.002740005 1 0.00275124166667 1 0.00275125166667 0 0.002759995 0 0.002760005 1 0.00277124166667 1 0.00277125166667 0 0.002779995 0 0.002780005 1 0.00279124166667 1 0.00279125166667 0 0.002799995 0 0.002800005 1 0.00281124166667 1
+ 0.00281125166667 0 0.002819995 0 0.002820005 1 0.00283124166667 1 0.00283125166667 0 0.002839995 0 0.002840005 1 0.00285124166667 1 0.00285125166667 0 0.002859995 0 0.002860005 1 0.00287124166667 1 0.00287125166667 0 0.002879995 0 0.002880005 1 0.00289124166667 1
+ 0.00289125166667 0 0.002899995 0 0.002900005 1 0.00291124166667 1 0.00291125166667 0 0.002919995 0 0.002920005 1 0.00293124166667 1 0.00293125166667 0 0.002939995 0 0.002940005 1 0.00295124166667 1 0.00295125166667 0 0.002959995 0 0.002960005 1 0.00297124166667 1
+ 0.00297125166667 0 0.002979995 0 0.002980005 1 0.00299124166667 1 0.00299125166667 0 0.002999995 0 0.003000005 1 0.00301124166667 1 0.00301125166667 0 0.003019995 0 0.003020005 1 0.00303124166667 1 0.00303125166667 0 0.003039995 0 0.003040005 1 0.00305124166667 1
+ 0.00305125166667 0 0.003059995 0 0.003060005 1 0.00307124166667 1 0.00307125166667 0 0.003079995 0 0.003080005 1 0.00309124166667 1 0.00309125166667 0 0.003099995 0 0.003100005 1 0.00311124166667 1 0.00311125166667 0 0.003119995 0 0.003120005 1 0.00313124166667 1
+ 0.00313125166667 0 0.003139995 0 0.003140005 1 0.00315124166667 1 0.00315125166667 0 0.003159995 0 0.003160005 1 0.00317124166667 1 0.00317125166667 0 0.003179995 0 0.003180005 1 0.00319124166667 1 0.00319125166667 0 0.003199995 0 0.003200005 1 0.00321124166667 1
+ 0.00321125166667 0 0.003219995 0 0.003220005 1 0.00323124166667 1 0.00323125166667 0 0.003239995 0 0.003240005 1 0.00325124166667 1 0.00325125166667 0 0.003259995 0 0.003260005 1 0.00327124166667 1 0.00327125166667 0 0.003279995 0 0.003280005 1 0.00329124166667 1
+ 0.00329125166667 0 0.003299995 0 0.003300005 1 0.00331124166667 1 0.00331125166667 0 0.003319995 0 0.003320005 1 0.00333124166667 1 0.00333125166667 0 0.003339995 0 0.003340005 1 0.00335124166667 1 0.00335125166667 0 0.003359995 0 0.003360005 1 0.00337124166667 1
+ 0.00337125166667 0 0.003379995 0 0.003380005 1 0.00339124166667 1 0.00339125166667 0 0.003399995 0 0.003400005 1 0.00341124166667 1 0.00341125166667 0 0.003419995 0 0.003420005 1 0.00343124166667 1 0.00343125166667 0 0.003439995 0 0.003440005 1 0.00345124166667 1
+ 0.00345125166667 0 0.003459995 0 0.003460005 1 0.00347124166667 1 0.00347125166667 0 0.003479995 0 0.003480005 1 0.00349124166667 1 0.00349125166667 0 0.003499995 0 0.003500005 1 0.00351124166667 1 0.00351125166667 0 0.003519995 0 0.003520005 1 0.00353124166667 1
+ 0.00353125166667 0 0.003539995 0 0.003540005 1 0.00355124166667 1 0.00355125166667 0 0.003559995 0 0.003560005 1 0.00357124166667 1 0.00357125166667 0 0.003579995 0 0.003580005 1 0.00359124166667 1 0.00359125166667 0 0.003599995 0 0.003600005 1 0.00361124166667 1
+ 0.00361125166667 0 0.003619995 0 0.003620005 1 0.00363124166667 1 0.00363125166667 0 0.003639995 0 0.003640005 1 0.00365124166667 1 0.00365125166667 0 0.003659995 0 0.003660005 1 0.00367124166667 1 0.00367125166667 0 0.003679995 0 0.003680005 1 0.00369124166667 1
+ 0.00369125166667 0 0.003699995 0 0.003700005 1 0.00371124166667 1 0.00371125166667 0 0.003719995 0 0.003720005 1 0.00373124166667 1 0.00373125166667 0 0.003739995 0 0.003740005 1 0.00375124166667 1 0.00375125166667 0 0.003759995 0 0.003760005 1 0.00377124166667 1
+ 0.00377125166667 0 0.003779995 0 0.003780005 1 0.00379124166667 1 0.00379125166667 0 0.003799995 0 0.003800005 1 0.00381124166667 1 0.00381125166667 0 0.003819995 0 0.003820005 1 0.00383124166667 1 0.00383125166667 0 0.003839995 0 0.003840005 1 0.00385124166667 1
+ 0.00385125166667 0 0.003859995 0 0.003860005 1 0.00387124166667 1 0.00387125166667 0 0.003879995 0 0.003880005 1 0.00389124166667 1 0.00389125166667 0 0.003899995 0 0.003900005 1 0.00391124166667 1 0.00391125166667 0 0.003919995 0 0.003920005 1 0.00393124166667 1
+ 0.00393125166667 0 0.003939995 0 0.003940005 1 0.00395124166667 1 0.00395125166667 0 0.003959995 0 0.003960005 1 0.00397124166667 1 0.00397125166667 0 0.003979995 0 0.003980005 1 0.00399124166667 1 0.00399125166667 0 0.003999995 0 0.004000005 1 0.00401124166667 1
+ 0.00401125166667 0 0.004019995 0 0.004020005 1 0.00403124166667 1 0.00403125166667 0 0.004039995 0 0.004040005 1 0.00405124166667 1 0.00405125166667 0 0.004059995 0 0.004060005 1 0.00407124166667 1 0.00407125166667 0 0.004079995 0 0.004080005 1 0.00409124166667 1
+ 0.00409125166667 0 0.004099995 0 0.004100005 1 0.00411124166667 1 0.00411125166667 0 0.004119995 0 0.004120005 1 0.00413124166667 1 0.00413125166667 0 0.004139995 0 0.004140005 1 0.00415124166667 1 0.00415125166667 0 0.004159995 0 0.004160005 1 0.00417124166667 1
+ 0.00417125166667 0 0.004179995 0 0.004180005 1 0.00419124166667 1 0.00419125166667 0 0.004199995 0 0.004200005 1 0.00421124166667 1 0.00421125166667 0 0.004219995 0 0.004220005 1 0.00423124166667 1 0.00423125166667 0 0.004239995 0 0.004240005 1 0.00425124166667 1
+ 0.00425125166667 0 0.004259995 0 0.004260005 1 0.00427124166667 1 0.00427125166667 0 0.004279995 0 0.004280005 1 0.00429124166667 1 0.00429125166667 0 0.004299995 0 0.004300005 1 0.00431124166667 1 0.00431125166667 0 0.004319995 0 0.004320005 1 0.00433124166667 1
+ 0.00433125166667 0 0.004339995 0 0.004340005 1 0.00435124166667 1 0.00435125166667 0 0.004359995 0 0.004360005 1 0.00437124166667 1 0.00437125166667 0 0.004379995 0 0.004380005 1 0.00439124166667 1 0.00439125166667 0 0.004399995 0 0.004400005 1 0.00441124166667 1
+ 0.00441125166667 0 0.004419995 0 0.004420005 1 0.00443124166667 1 0.00443125166667 0 0.004439995 0 0.004440005 1 0.00445124166667 1 0.00445125166667 0 0.004459995 0 0.004460005 1 0.00447124166667 1 0.00447125166667 0 0.004479995 0 0.004480005 1 0.00449124166667 1
+ 0.00449125166667 0 0.004499995 0 0.004500005 1 0.00451124166667 1 0.00451125166667 0 0.004519995 0 0.004520005 1 0.00453124166667 1 0.00453125166667 0 0.004539995 0 0.004540005 1 0.00455124166667 1 0.00455125166667 0 0.004559995 0 0.004560005 1 0.00457124166667 1
+ 0.00457125166667 0 0.004579995 0 0.004580005 1 0.00459124166667 1 0.00459125166667 0 0.004599995 0 0.004600005 1 0.00461124166667 1 0.00461125166667 0 0.004619995 0 0.004620005 1 0.00463124166667 1 0.00463125166667 0 0.004639995 0 0.004640005 1 0.00465124166667 1
+ 0.00465125166667 0 0.004659995 0 0.004660005 1 0.00467124166667 1 0.00467125166667 0 0.004679995 0 0.004680005 1 0.00469124166667 1 0.00469125166667 0 0.004699995 0 0.004700005 1 0.00471124166667 1 0.00471125166667 0 0.004719995 0 0.004720005 1 0.00473124166667 1
+ 0.00473125166667 0 0.004739995 0 0.004740005 1 0.00475124166667 1 0.00475125166667 0 0.004759995 0 0.004760005 1 0.00477124166667 1 0.00477125166667 0 0.004779995 0 0.004780005 1 0.00479124166667 1 0.00479125166667 0 0.004799995 0 0.004800005 1 0.00481124166667 1
+ 0.00481125166667 0 0.004819995 0 0.004820005 1 0.00483124166667 1 0.00483125166667 0 0.004839995 0 0.004840005 1 0.00485124166667 1 0.00485125166667 0 0.004859995 0 0.004860005 1 0.00487124166667 1 0.00487125166667 0 0.004879995 0 0.004880005 1 0.00489124166667 1
+ 0.00489125166667 0 0.004899995 0 0.004900005 1 0.00491124166667 1 0.00491125166667 0 0.004919995 0 0.004920005 1 0.00493124166667 1 0.00493125166667 0 0.004939995 0 0.004940005 1 0.00495124166667 1 0.00495125166667 0 0.004959995 0 0.004960005 1 0.00497124166667 1
+ 0.00497125166667 0 0.004979995 0 0.004980005 1 0.00499124166667 1 0.00499125166667 0 0.004999995 0 0.005000005 1 0.00501124166667 1 0.00501125166667 0 0.005019995 0 0.005020005 1 0.00503124166667 1 0.00503125166667 0 0.005039995 0 0.005040005 1 0.00505124166667 1
+ 0.00505125166667 0 0.005059995 0 0.005060005 1 0.00507124166667 1 0.00507125166667 0 0.005079995 0 0.005080005 1 0.00509124166667 1 0.00509125166667 0 0.005099995 0 0.005100005 1 0.00511124166667 1 0.00511125166667 0 0.005119995 0 0.005120005 1 0.00513124166667 1
+ 0.00513125166667 0 0.005139995 0 0.005140005 1 0.00515124166667 1 0.00515125166667 0 0.005159995 0 0.005160005 1 0.00517124166667 1 0.00517125166667 0 0.005179995 0 0.005180005 1 0.00519124166667 1 0.00519125166667 0 0.005199995 0 0.005200005 1 0.00521124166667 1
+ 0.00521125166667 0 0.005219995 0 0.005220005 1 0.00523124166667 1 0.00523125166667 0 0.005239995 0 0.005240005 1 0.00525124166667 1 0.00525125166667 0 0.005259995 0 0.005260005 1 0.00527124166667 1 0.00527125166667 0 0.005279995 0 0.005280005 1 0.00529124166667 1
+ 0.00529125166667 0 0.005299995 0 0.005300005 1 0.00531124166667 1 0.00531125166667 0 0.005319995 0 0.005320005 1 0.00533124166667 1 0.00533125166667 0 0.005339995 0 0.005340005 1 0.00535124166667 1 0.00535125166667 0 0.005359995 0 0.005360005 1 0.00537124166667 1
+ 0.00537125166667 0 0.005379995 0 0.005380005 1 0.00539124166667 1 0.00539125166667 0 0.005399995 0 0.005400005 1 0.00541124166667 1 0.00541125166667 0 0.005419995 0 0.005420005 1 0.00543124166667 1 0.00543125166667 0 0.005439995 0 0.005440005 1 0.00545124166667 1
+ 0.00545125166667 0 0.005459995 0 0.005460005 1 0.00547124166667 1 0.00547125166667 0 0.005479995 0 0.005480005 1 0.00549124166667 1 0.00549125166667 0 0.005499995 0 0.005500005 1 0.00551124166667 1 0.00551125166667 0 0.005519995 0 0.005520005 1 0.00553124166667 1
+ 0.00553125166667 0 0.005539995 0 0.005540005 1 0.00555124166667 1 0.00555125166667 0 0.005559995 0 0.005560005 1 0.00557124166667 1 0.00557125166667 0 0.005579995 0 0.005580005 1 0.00559124166667 1 0.00559125166667 0 0.005599995 0 0.005600005 1 0.00561124166667 1
+ 0.00561125166667 0 0.005619995 0 0.005620005 1 0.00563124166667 1 0.00563125166667 0 0.005639995 0 0.005640005 1 0.00565124166667 1 0.00565125166667 0 0.005659995 0 0.005660005 1 0.00567124166667 1 0.00567125166667 0 0.005679995 0 0.005680005 1 0.00569124166667 1
+ 0.00569125166667 0 0.005699995 0 0.005700005 1 0.00571124166667 1 0.00571125166667 0 0.005719995 0 0.005720005 1 0.00573124166667 1 0.00573125166667 0 0.005739995 0 0.005740005 1 0.00575124166667 1 0.00575125166667 0 0.005759995 0 0.005760005 1 0.00577124166667 1
+ 0.00577125166667 0 0.005779995 0 0.005780005 1 0.00579124166667 1 0.00579125166667 0 0.005799995 0 0.005800005 1 0.00581124166667 1 0.00581125166667 0 0.005819995 0 0.005820005 1 0.00583124166667 1 0.00583125166667 0 0.005839995 0 0.005840005 1 0.00585124166667 1
+ 0.00585125166667 0 0.005859995 0 0.005860005 1 0.00587124166667 1 0.00587125166667 0 0.005879995 0 0.005880005 1 0.00589124166667 1 0.00589125166667 0 0.005899995 0 0.005900005 1 0.00591124166667 1 0.00591125166667 0 0.005919995 0 0.005920005 1 0.00593124166667 1
+ 0.00593125166667 0 0.005939995 0 0.005940005 1 0.00595124166667 1 0.00595125166667 0 0.005959995 0 0.005960005 1 0.00597124166667 1 0.00597125166667 0 0.005979995 0 0.005980005 1 0.00599124166667 1 0.00599125166667 0 0.005999995 0 0.006000005 1 0.00601124166667 1
+ 0.00601125166667 0 0.006019995 0 0.006020005 1 0.00603124166667 1 0.00603125166667 0 0.006039995 0 0.006040005 1 0.00605124166667 1 0.00605125166667 0 0.006059995 0 0.006060005 1 0.00607124166667 1 0.00607125166667 0 0.006079995 0 0.006080005 1 0.00609124166667 1
+ 0.00609125166667 0 0.006099995 0 0.006100005 1 0.00611124166667 1 0.00611125166667 0 0.006119995 0 0.006120005 1 0.00613124166667 1 0.00613125166667 0 0.006139995 0 0.006140005 1 0.00615124166667 1 0.00615125166667 0 0.006159995 0 0.006160005 1 0.00617124166667 1
+ 0.00617125166667 0 0.006179995 0 0.006180005 1 0.00619124166667 1 0.00619125166667 0 0.006199995 0 0.006200005 1 0.00621124166667 1 0.00621125166667 0 0.006219995 0 0.006220005 1 0.00623124166667 1 0.00623125166667 0 0.006239995 0 0.006240005 1 0.00625124166667 1
+ 0.00625125166667 0 0.006259995 0 0.006260005 1 0.00627124166667 1 0.00627125166667 0 0.006279995 0 0.006280005 1 0.00629124166667 1 0.00629125166667 0 0.006299995 0 0.006300005 1 0.00631124166667 1 0.00631125166667 0 0.006319995 0 0.006320005 1 0.00633124166667 1
+ 0.00633125166667 0 0.006339995 0 0.006340005 1 0.00635124166667 1 0.00635125166667 0 0.006359995 0 0.006360005 1 0.00637124166667 1 0.00637125166667 0 0.006379995 0 0.006380005 1 0.00639124166667 1 0.00639125166667 0 0.006399995 0 0.006400005 1 0.00641124166667 1
+ 0.00641125166667 0 0.006419995 0 0.006420005 1 0.00643124166667 1 0.00643125166667 0 0.006439995 0 0.006440005 1 0.00645124166667 1 0.00645125166667 0 0.006459995 0 0.006460005 1 0.00647124166667 1 0.00647125166667 0 0.006479995 0 0.006480005 1 0.00649124166667 1
+ 0.00649125166667 0 0.006499995 0 0.006500005 1 0.00651124166667 1 0.00651125166667 0 0.006519995 0 0.006520005 1 0.00653124166667 1 0.00653125166667 0 0.006539995 0 0.006540005 1 0.00655124166667 1 0.00655125166667 0 0.006559995 0 0.006560005 1 0.00657124166667 1
+ 0.00657125166667 0 0.006579995 0 0.006580005 1 0.00659124166667 1 0.00659125166667 0 0.006599995 0 0.006600005 1 0.00661124166667 1 0.00661125166667 0 0.006619995 0 0.006620005 1 0.00663124166667 1 0.00663125166667 0 0.006639995 0 0.006640005 1 0.00665124166667 1
+ 0.00665125166667 0 0.006659995 0 0.006660005 1 0.00667124166667 1 0.00667125166667 0 0.006679995 0 0.006680005 1 0.00669124166667 1 0.00669125166667 0 0.006699995 0 0.006700005 1 0.00671124166667 1 0.00671125166667 0 0.006719995 0 0.006720005 1 0.00673124166667 1
+ 0.00673125166667 0 0.006739995 0 0.006740005 1 0.00675124166667 1 0.00675125166667 0 0.006759995 0 0.006760005 1 0.00677124166667 1 0.00677125166667 0 0.006779995 0 0.006780005 1 0.00679124166667 1 0.00679125166667 0 0.006799995 0 0.006800005 1 0.00681124166667 1
+ 0.00681125166667 0 0.006819995 0 0.006820005 1 0.00683124166667 1 0.00683125166667 0 0.006839995 0 0.006840005 1 0.00685124166667 1 0.00685125166667 0 0.006859995 0 0.006860005 1 0.00687124166667 1 0.00687125166667 0 0.006879995 0 0.006880005 1 0.00689124166667 1
+ 0.00689125166667 0 0.006899995 0 0.006900005 1 0.00691124166667 1 0.00691125166667 0 0.006919995 0 0.006920005 1 0.00693124166667 1 0.00693125166667 0 0.006939995 0 0.006940005 1 0.00695124166667 1 0.00695125166667 0 0.006959995 0 0.006960005 1 0.00697124166667 1
+ 0.00697125166667 0 0.006979995 0 0.006980005 1 0.00699124166667 1 0.00699125166667 0 0.006999995 0 0.007000005 1 0.00701124166667 1 0.00701125166667 0 0.007019995 0 0.007020005 1 0.00703124166667 1 0.00703125166667 0 0.007039995 0 0.007040005 1 0.00705124166667 1
+ 0.00705125166667 0 0.007059995 0 0.007060005 1 0.00707124166667 1 0.00707125166667 0 0.007079995 0 0.007080005 1 0.00709124166667 1 0.00709125166667 0 0.007099995 0 0.007100005 1 0.00711124166667 1 0.00711125166667 0 0.007119995 0 0.007120005 1 0.00713124166667 1
+ 0.00713125166667 0 0.007139995 0 0.007140005 1 0.00715124166667 1 0.00715125166667 0 0.007159995 0 0.007160005 1 0.00717124166667 1 0.00717125166667 0 0.007179995 0 0.007180005 1 0.00719124166667 1 0.00719125166667 0 0.007199995 0 0.007200005 1 0.00721124166667 1
+ 0.00721125166667 0 0.007219995 0 0.007220005 1 0.00723124166667 1 0.00723125166667 0 0.007239995 0 0.007240005 1 0.00725124166667 1 0.00725125166667 0 0.007259995 0 0.007260005 1 0.00727124166667 1 0.00727125166667 0 0.007279995 0 0.007280005 1 0.00729124166667 1
+ 0.00729125166667 0 0.007299995 0 0.007300005 1 0.00731124166667 1 0.00731125166667 0 0.007319995 0 0.007320005 1 0.00733124166667 1 0.00733125166667 0 0.007339995 0 0.007340005 1 0.00735124166667 1 0.00735125166667 0 0.007359995 0 0.007360005 1 0.00737124166667 1
+ 0.00737125166667 0 0.007379995 0 0.007380005 1 0.00739124166667 1 0.00739125166667 0 0.007399995 0 0.007400005 1 0.00741124166667 1 0.00741125166667 0 0.007419995 0 0.007420005 1 0.00743124166667 1 0.00743125166667 0 0.007439995 0 0.007440005 1 0.00745124166667 1
+ 0.00745125166667 0 0.007459995 0 0.007460005 1 0.00747124166667 1 0.00747125166667 0 0.007479995 0 0.007480005 1 0.00749124166667 1 0.00749125166667 0 0.007499995 0 0.007500005 1 0.00751124166667 1 0.00751125166667 0 0.007519995 0 0.007520005 1 0.00753124166667 1
+ 0.00753125166667 0 0.007539995 0 0.007540005 1 0.00755124166667 1 0.00755125166667 0 0.007559995 0 0.007560005 1 0.00757124166667 1 0.00757125166667 0 0.007579995 0 0.007580005 1 0.00759124166667 1 0.00759125166667 0 0.007599995 0 0.007600005 1 0.00761124166667 1
+ 0.00761125166667 0 0.007619995 0 0.007620005 1 0.00763124166667 1 0.00763125166667 0 0.007639995 0 0.007640005 1 0.00765124166667 1 0.00765125166667 0 0.007659995 0 0.007660005 1 0.00767124166667 1 0.00767125166667 0 0.007679995 0 0.007680005 1 0.00769124166667 1
+ 0.00769125166667 0 0.007699995 0 0.007700005 1 0.00771124166667 1 0.00771125166667 0 0.007719995 0 0.007720005 1 0.00773124166667 1 0.00773125166667 0 0.007739995 0 0.007740005 1 0.00775124166667 1 0.00775125166667 0 0.007759995 0 0.007760005 1 0.00777124166667 1
+ 0.00777125166667 0 0.007779995 0 0.007780005 1 0.00779124166667 1 0.00779125166667 0 0.007799995 0 0.007800005 1 0.00781124166667 1 0.00781125166667 0 0.007819995 0 0.007820005 1 0.00783124166667 1 0.00783125166667 0 0.007839995 0 0.007840005 1 0.00785124166667 1
+ 0.00785125166667 0 0.007859995 0 0.007860005 1 0.00787124166667 1 0.00787125166667 0 0.007879995 0 0.007880005 1 0.00789124166667 1 0.00789125166667 0 0.007899995 0 0.007900005 1 0.00791124166667 1 0.00791125166667 0 0.007919995 0 0.007920005 1 0.00793124166667 1
+ 0.00793125166667 0 0.007939995 0 0.007940005 1 0.00795124166667 1 0.00795125166667 0 0.007959995 0 0.007960005 1 0.00797124166667 1 0.00797125166667 0 0.007979995 0 0.007980005 1 0.00799124166667 1 0.00799125166667 0 0.007999995 0 0.008000005 1 0.00801124166667 1
+ 0.00801125166667 0 0.008019995 0 0.008020005 1 0.00803124166667 1 0.00803125166667 0 0.008039995 0 0.008040005 1 0.00805124166667 1 0.00805125166667 0 0.008059995 0 0.008060005 1 0.00807124166667 1 0.00807125166667 0 0.008079995 0 0.008080005 1 0.00809124166667 1
+ 0.00809125166667 0 0.008099995 0 0.008100005 1 0.00811124166667 1 0.00811125166667 0 0.008119995 0 0.008120005 1 0.00813124166667 1 0.00813125166667 0 0.008139995 0 0.008140005 1 0.00815124166667 1 0.00815125166667 0 0.008159995 0 0.008160005 1 0.00817124166667 1
+ 0.00817125166667 0 0.008179995 0 0.008180005 1 0.00819124166667 1 0.00819125166667 0 0.008199995 0 0.008200005 1 0.00821124166667 1 0.00821125166667 0 0.008219995 0 0.008220005 1 0.00823124166667 1 0.00823125166667 0 0.008239995 0 0.008240005 1 0.00825124166667 1
+ 0.00825125166667 0 0.008259995 0 0.008260005 1 0.00827124166667 1 0.00827125166667 0 0.008279995 0 0.008280005 1 0.00829124166667 1 0.00829125166667 0 0.008299995 0 0.008300005 1 0.00831124166667 1 0.00831125166667 0 0.008319995 0 0.008320005 1 0.00833124166667 1
+ 0.00833125166667 0 0.008339995 0 0.008340005 1 0.00835124166667 1 0.00835125166667 0 0.008359995 0 0.008360005 1 0.00837124166667 1 0.00837125166667 0 0.008379995 0 0.008380005 1 0.00839124166667 1 0.00839125166667 0 0.008399995 0 0.008400005 1 0.00841124166667 1
+ 0.00841125166667 0 0.008419995 0 0.008420005 1 0.00843124166667 1 0.00843125166667 0 0.008439995 0 0.008440005 1 0.00845124166667 1 0.00845125166667 0 0.008459995 0 0.008460005 1 0.00847124166667 1 0.00847125166667 0 0.008479995 0 0.008480005 1 0.00849124166667 1
+ 0.00849125166667 0 0.008499995 0 0.008500005 1 0.00851124166667 1 0.00851125166667 0 0.008519995 0 0.008520005 1 0.00853124166667 1 0.00853125166667 0 0.008539995 0 0.008540005 1 0.00855124166667 1 0.00855125166667 0 0.008559995 0 0.008560005 1 0.00857124166667 1
+ 0.00857125166667 0 0.008579995 0 0.008580005 1 0.00859124166667 1 0.00859125166667 0 0.008599995 0 0.008600005 1 0.00861124166667 1 0.00861125166667 0 0.008619995 0 0.008620005 1 0.00863124166667 1 0.00863125166667 0 0.008639995 0 0.008640005 1 0.00865124166667 1
+ 0.00865125166667 0 0.008659995 0 0.008660005 1 0.00867124166667 1 0.00867125166667 0 0.008679995 0 0.008680005 1 0.00869124166667 1 0.00869125166667 0 0.008699995 0 0.008700005 1 0.00871124166667 1 0.00871125166667 0 0.008719995 0 0.008720005 1 0.00873124166667 1
+ 0.00873125166667 0 0.008739995 0 0.008740005 1 0.00875124166667 1 0.00875125166667 0 0.008759995 0 0.008760005 1 0.00877124166667 1 0.00877125166667 0 0.008779995 0 0.008780005 1 0.00879124166667 1 0.00879125166667 0 0.008799995 0 0.008800005 1 0.00881124166667 1
+ 0.00881125166667 0 0.008819995 0 0.008820005 1 0.00883124166667 1 0.00883125166667 0 0.008839995 0 0.008840005 1 0.00885124166667 1 0.00885125166667 0 0.008859995 0 0.008860005 1 0.00887124166667 1 0.00887125166667 0 0.008879995 0 0.008880005 1 0.00889124166667 1
+ 0.00889125166667 0 0.008899995 0 0.008900005 1 0.00891124166667 1 0.00891125166667 0 0.008919995 0 0.008920005 1 0.00893124166667 1 0.00893125166667 0 0.008939995 0 0.008940005 1 0.00895124166667 1 0.00895125166667 0 0.008959995 0 0.008960005 1 0.00897124166667 1
+ 0.00897125166667 0 0.008979995 0 0.008980005 1 0.00899124166667 1 0.00899125166667 0 0.008999995 0 0.009000005 1 0.00901124166667 1 0.00901125166667 0 0.009019995 0 0.009020005 1 0.00903124166667 1 0.00903125166667 0 0.009039995 0 0.009040005 1 0.00905124166667 1
+ 0.00905125166667 0 0.009059995 0 0.009060005 1 0.00907124166667 1 0.00907125166667 0 0.009079995 0 0.009080005 1 0.00909124166667 1 0.00909125166667 0 0.009099995 0 0.009100005 1 0.00911124166667 1 0.00911125166667 0 0.009119995 0 0.009120005 1 0.00913124166667 1
+ 0.00913125166667 0 0.009139995 0 0.009140005 1 0.00915124166667 1 0.00915125166667 0 0.009159995 0 0.009160005 1 0.00917124166667 1 0.00917125166667 0 0.009179995 0 0.009180005 1 0.00919124166667 1 0.00919125166667 0 0.009199995 0 0.009200005 1 0.00921124166667 1
+ 0.00921125166667 0 0.009219995 0 0.009220005 1 0.00923124166667 1 0.00923125166667 0 0.009239995 0 0.009240005 1 0.00925124166667 1 0.00925125166667 0 0.009259995 0 0.009260005 1 0.00927124166667 1 0.00927125166667 0 0.009279995 0 0.009280005 1 0.00929124166667 1
+ 0.00929125166667 0 0.009299995 0 0.009300005 1 0.00931124166667 1 0.00931125166667 0 0.009319995 0 0.009320005 1 0.00933124166667 1 0.00933125166667 0 0.009339995 0 0.009340005 1 0.00935124166667 1 0.00935125166667 0 0.009359995 0 0.009360005 1 0.00937124166667 1
+ 0.00937125166667 0 0.009379995 0 0.009380005 1 0.00939124166667 1 0.00939125166667 0 0.009399995 0 0.009400005 1 0.00941124166667 1 0.00941125166667 0 0.009419995 0 0.009420005 1 0.00943124166667 1 0.00943125166667 0 0.009439995 0 0.009440005 1 0.00945124166667 1
+ 0.00945125166667 0 0.009459995 0 0.009460005 1 0.00947124166667 1 0.00947125166667 0 0.009479995 0 0.009480005 1 0.00949124166667 1 0.00949125166667 0 0.009499995 0 0.009500005 1 0.00951124166667 1 0.00951125166667 0 0.009519995 0 0.009520005 1 0.00953124166667 1
+ 0.00953125166667 0 0.009539995 0 0.009540005 1 0.00955124166667 1 0.00955125166667 0 0.009559995 0 0.009560005 1 0.00957124166667 1 0.00957125166667 0 0.009579995 0 0.009580005 1 0.00959124166667 1 0.00959125166667 0 0.009599995 0 0.009600005 1 0.00961124166667 1
+ 0.00961125166667 0 0.009619995 0 0.009620005 1 0.00963124166667 1 0.00963125166667 0 0.009639995 0 0.009640005 1 0.00965124166667 1 0.00965125166667 0 0.009659995 0 0.009660005 1 0.00967124166667 1 0.00967125166667 0 0.009679995 0 0.009680005 1 0.00969124166667 1
+ 0.00969125166667 0 0.009699995 0 0.009700005 1 0.00971124166667 1 0.00971125166667 0 0.009719995 0 0.009720005 1 0.00973124166667 1 0.00973125166667 0 0.009739995 0 0.009740005 1 0.00975124166667 1 0.00975125166667 0 0.009759995 0 0.009760005 1 0.00977124166667 1
+ 0.00977125166667 0 0.009779995 0 0.009780005 1 0.00979124166667 1 0.00979125166667 0 0.009799995 0 0.009800005 1 0.00981124166667 1 0.00981125166667 0 0.009819995 0 0.009820005 1 0.00983124166667 1 0.00983125166667 0 0.009839995 0 0.009840005 1 0.00985124166667 1
+ 0.00985125166667 0 0.009859995 0 0.009860005 1 0.00987124166667 1 0.00987125166667 0 0.009879995 0 0.009880005 1 0.00989124166667 1 0.00989125166667 0 0.009899995 0 0.009900005 1 0.00991124166667 1 0.00991125166667 0 0.009919995 0 0.009920005 1 0.00993124166667 1
+ 0.00993125166667 0 0.009939995 0 0.009940005 1 0.00995124166667 1 0.00995125166667 0 0.009959995 0 0.009960005 1 0.00997124166667 1 0.00997125166667 0 0.009979995 0 0.009980005 1 0.00999124166667 1 0.00999125166667 0 0.009999995 0 0.010000005 1 0.0100112416667 1
+ 0.0100112516667 0 0.010019995 0 0.010020005 1 0.0100312416667 1 0.0100312516667 0 0.010039995 0 0.010040005 1 0.0100512416667 1 0.0100512516667 0 0.010059995 0 0.010060005 1 0.0100712416667 1 0.0100712516667 0 0.010079995 0 0.010080005 1 0.0100912416667 1
+ 0.0100912516667 0 0.010099995 0 0.010100005 1 0.0101112416667 1 0.0101112516667 0 0.010119995 0 0.010120005 1 0.0101312416667 1 0.0101312516667 0 0.010139995 0 0.010140005 1 0.0101512416667 1 0.0101512516667 0 0.010159995 0 0.010160005 1 0.0101712416667 1
+ 0.0101712516667 0 0.010179995 0 0.010180005 1 0.0101912416667 1 0.0101912516667 0 0.010199995 0 0.010200005 1 0.0102112416667 1 0.0102112516667 0 0.010219995 0 0.010220005 1 0.0102312416667 1 0.0102312516667 0 0.010239995 0 0.010240005 1 0.0102512416667 1
+ 0.0102512516667 0 0.010259995 0 0.010260005 1 0.0102712416667 1 0.0102712516667 0 0.010279995 0 0.010280005 1 0.0102912416667 1 0.0102912516667 0 0.010299995 0 0.010300005 1 0.0103112416667 1 0.0103112516667 0 0.010319995 0 0.010320005 1 0.0103312416667 1
+ 0.0103312516667 0 0.010339995 0 0.010340005 1 0.0103512416667 1 0.0103512516667 0 0.010359995 0 0.010360005 1 0.0103712416667 1 0.0103712516667 0 0.010379995 0 0.010380005 1 0.0103912416667 1 0.0103912516667 0 0.010399995 0 0.010400005 1 0.0104112416667 1
+ 0.0104112516667 0 0.010419995 0 0.010420005 1 0.0104312416667 1 0.0104312516667 0 0.010439995 0 0.010440005 1 0.0104512416667 1 0.0104512516667 0 0.010459995 0 0.010460005 1 0.0104712416667 1 0.0104712516667 0 0.010479995 0 0.010480005 1 0.0104912416667 1
+ 0.0104912516667 0 0.010499995 0 0.010500005 1 0.0105112416667 1 0.0105112516667 0 0.010519995 0 0.010520005 1 0.0105312416667 1 0.0105312516667 0 0.010539995 0 0.010540005 1 0.0105512416667 1 0.0105512516667 0 0.010559995 0 0.010560005 1 0.0105712416667 1
+ 0.0105712516667 0 0.010579995 0 0.010580005 1 0.0105912416667 1 0.0105912516667 0 0.010599995 0 0.010600005 1 0.0106112416667 1 0.0106112516667 0 0.010619995 0 0.010620005 1 0.0106312416667 1 0.0106312516667 0 0.010639995 0 0.010640005 1 0.0106512416667 1
+ 0.0106512516667 0 0.010659995 0 0.010660005 1 0.0106712416667 1 0.0106712516667 0 0.010679995 0 0.010680005 1 0.0106912416667 1 0.0106912516667 0 0.010699995 0 0.010700005 1 0.0107112416667 1 0.0107112516667 0 0.010719995 0 0.010720005 1 0.0107312416667 1
+ 0.0107312516667 0 0.010739995 0 0.010740005 1 0.0107512416667 1 0.0107512516667 0 0.010759995 0 0.010760005 1 0.0107712416667 1 0.0107712516667 0 0.010779995 0 0.010780005 1 0.0107912416667 1 0.0107912516667 0 0.010799995 0 0.010800005 1 0.0108112416667 1
+ 0.0108112516667 0 0.010819995 0 0.010820005 1 0.0108312416667 1 0.0108312516667 0 0.010839995 0 0.010840005 1 0.0108512416667 1 0.0108512516667 0 0.010859995 0 0.010860005 1 0.0108712416667 1 0.0108712516667 0 0.010879995 0 0.010880005 1 0.0108912416667 1
+ 0.0108912516667 0 0.010899995 0 0.010900005 1 0.0109112416667 1 0.0109112516667 0 0.010919995 0 0.010920005 1 0.0109312416667 1 0.0109312516667 0 0.010939995 0 0.010940005 1 0.0109512416667 1 0.0109512516667 0 0.010959995 0 0.010960005 1 0.0109712416667 1
+ 0.0109712516667 0 0.010979995 0 0.010980005 1 0.0109912416667 1 0.0109912516667 0 0.010999995 0 0.011000005 1 0.0110112416667 1 0.0110112516667 0 0.011019995 0 0.011020005 1 0.0110312416667 1 0.0110312516667 0 0.011039995 0 0.011040005 1 0.0110512416667 1
+ 0.0110512516667 0 0.011059995 0 0.011060005 1 0.0110712416667 1 0.0110712516667 0 0.011079995 0 0.011080005 1 0.0110912416667 1 0.0110912516667 0 0.011099995 0 0.011100005 1 0.0111112416667 1 0.0111112516667 0 0.011119995 0 0.011120005 1 0.0111312416667 1
+ 0.0111312516667 0 0.011139995 0 0.011140005 1 0.0111512416667 1 0.0111512516667 0 0.011159995 0 0.011160005 1 0.0111712416667 1 0.0111712516667 0 0.011179995 0 0.011180005 1 0.0111912416667 1 0.0111912516667 0 0.011199995 0 0.011200005 1 0.0112112416667 1
+ 0.0112112516667 0 0.011219995 0 0.011220005 1 0.0112312416667 1 0.0112312516667 0 0.011239995 0 0.011240005 1 0.0112512416667 1 0.0112512516667 0 0.011259995 0 0.011260005 1 0.0112712416667 1 0.0112712516667 0 0.011279995 0 0.011280005 1 0.0112912416667 1
+ 0.0112912516667 0 0.011299995 0 0.011300005 1 0.0113112416667 1 0.0113112516667 0 0.011319995 0 0.011320005 1 0.0113312416667 1 0.0113312516667 0 0.011339995 0 0.011340005 1 0.0113512416667 1 0.0113512516667 0 0.011359995 0 0.011360005 1 0.0113712416667 1
+ 0.0113712516667 0 0.011379995 0 0.011380005 1 0.0113912416667 1 0.0113912516667 0 0.011399995 0 0.011400005 1 0.0114112416667 1 0.0114112516667 0 0.011419995 0 0.011420005 1 0.0114312416667 1 0.0114312516667 0 0.011439995 0 0.011440005 1 0.0114512416667 1
+ 0.0114512516667 0 0.011459995 0 0.011460005 1 0.0114712416667 1 0.0114712516667 0 0.011479995 0 0.011480005 1 0.0114912416667 1 0.0114912516667 0 0.011499995 0 0.011500005 1 0.0115112416667 1 0.0115112516667 0 0.011519995 0 0.011520005 1 0.0115312416667 1
+ 0.0115312516667 0 0.011539995 0 0.011540005 1 0.0115512416667 1 0.0115512516667 0 0.011559995 0 0.011560005 1 0.0115712416667 1 0.0115712516667 0 0.011579995 0 0.011580005 1 0.0115912416667 1 0.0115912516667 0 0.011599995 0 0.011600005 1 0.0116112416667 1
+ 0.0116112516667 0 0.011619995 0 0.011620005 1 0.0116312416667 1 0.0116312516667 0 0.011639995 0 0.011640005 1 0.0116512416667 1 0.0116512516667 0 0.011659995 0 0.011660005 1 0.0116712416667 1 0.0116712516667 0 0.011679995 0 0.011680005 1 0.0116912416667 1
+ 0.0116912516667 0 0.011699995 0 0.011700005 1 0.0117112416667 1 0.0117112516667 0 0.011719995 0 0.011720005 1 0.0117312416667 1 0.0117312516667 0 0.011739995 0 0.011740005 1 0.0117512416667 1 0.0117512516667 0 0.011759995 0 0.011760005 1 0.0117712416667 1
+ 0.0117712516667 0 0.011779995 0 0.011780005 1 0.0117912416667 1 0.0117912516667 0 0.011799995 0 0.011800005 1 0.0118112416667 1 0.0118112516667 0 0.011819995 0 0.011820005 1 0.0118312416667 1 0.0118312516667 0 0.011839995 0 0.011840005 1 0.0118512416667 1
+ 0.0118512516667 0 0.011859995 0 0.011860005 1 0.0118712416667 1 0.0118712516667 0 0.011879995 0 0.011880005 1 0.0118912416667 1 0.0118912516667 0 0.011899995 0 0.011900005 1 0.0119112416667 1 0.0119112516667 0 0.011919995 0 0.011920005 1 0.0119312416667 1
+ 0.0119312516667 0 0.011939995 0 0.011940005 1 0.0119512416667 1 0.0119512516667 0 0.011959995 0 0.011960005 1 0.0119712416667 1 0.0119712516667 0 0.011979995 0 0.011980005 1 0.0119912416667 1 0.0119912516667 0 0.011999995 0 0.012000005 1 0.0120112416667 1
+ 0.0120112516667 0 0.012019995 0 0.012020005 1 0.0120312416667 1 0.0120312516667 0 0.012039995 0 0.012040005 1 0.0120512416667 1 0.0120512516667 0 0.012059995 0 0.012060005 1 0.0120712416667 1 0.0120712516667 0 0.012079995 0 0.012080005 1 0.0120912416667 1
+ 0.0120912516667 0 0.012099995 0 0.012100005 1 0.0121112416667 1 0.0121112516667 0 0.012119995 0 0.012120005 1 0.0121312416667 1 0.0121312516667 0 0.012139995 0 0.012140005 1 0.0121512416667 1 0.0121512516667 0 0.012159995 0 0.012160005 1 0.0121712416667 1
+ 0.0121712516667 0 0.012179995 0 0.012180005 1 0.0121912416667 1 0.0121912516667 0 0.012199995 0 0.012200005 1 0.0122112416667 1 0.0122112516667 0 0.012219995 0 0.012220005 1 0.0122312416667 1 0.0122312516667 0 0.012239995 0 0.012240005 1 0.0122512416667 1
+ 0.0122512516667 0 0.012259995 0 0.012260005 1 0.0122712416667 1 0.0122712516667 0 0.012279995 0 0.012280005 1 0.0122912416667 1 0.0122912516667 0 0.012299995 0 0.012300005 1 0.0123112416667 1 0.0123112516667 0 0.012319995 0 0.012320005 1 0.0123312416667 1
+ 0.0123312516667 0 0.012339995 0 0.012340005 1 0.0123512416667 1 0.0123512516667 0 0.012359995 0 0.012360005 1 0.0123712416667 1 0.0123712516667 0 0.012379995 0 0.012380005 1 0.0123912416667 1 0.0123912516667 0 0.012399995 0 0.012400005 1 0.0124112416667 1
+ 0.0124112516667 0 0.012419995 0 0.012420005 1 0.0124312416667 1 0.0124312516667 0 0.012439995 0 0.012440005 1 0.0124512416667 1 0.0124512516667 0 0.012459995 0 0.012460005 1 0.0124712416667 1 0.0124712516667 0 0.012479995 0 0.012480005 1 0.0124912416667 1
+ 0.0124912516667 0 0.012499995 0 0.012500005 1 0.0125112416667 1 0.0125112516667 0 0.012519995 0 0.012520005 1 0.0125312416667 1 0.0125312516667 0 0.012539995 0 0.012540005 1 0.0125512416667 1 0.0125512516667 0 0.012559995 0 0.012560005 1 0.0125712416667 1
+ 0.0125712516667 0 0.012579995 0 0.012580005 1 0.0125912416667 1 0.0125912516667 0 0.012599995 0 0.012600005 1 0.0126112416667 1 0.0126112516667 0 0.012619995 0 0.012620005 1 0.0126312416667 1 0.0126312516667 0 0.012639995 0 0.012640005 1 0.0126512416667 1
+ 0.0126512516667 0 0.012659995 0 0.012660005 1 0.0126712416667 1 0.0126712516667 0 0.012679995 0 0.012680005 1 0.0126912416667 1 0.0126912516667 0 0.012699995 0 0.012700005 1 0.0127112416667 1 0.0127112516667 0 0.012719995 0 0.012720005 1 0.0127312416667 1
+ 0.0127312516667 0 0.012739995 0 0.012740005 1 0.0127512416667 1 0.0127512516667 0 0.012759995 0 0.012760005 1 0.0127712416667 1 0.0127712516667 0 0.012779995 0 0.012780005 1 0.0127912416667 1 0.0127912516667 0 0.012799995 0 0.012800005 1 0.0128112416667 1
+ 0.0128112516667 0 0.012819995 0 0.012820005 1 0.0128312416667 1 0.0128312516667 0 0.012839995 0 0.012840005 1 0.0128512416667 1 0.0128512516667 0 0.012859995 0 0.012860005 1 0.0128712416667 1 0.0128712516667 0 0.012879995 0 0.012880005 1 0.0128912416667 1
+ 0.0128912516667 0 0.012899995 0 0.012900005 1 0.0129112416667 1 0.0129112516667 0 0.012919995 0 0.012920005 1 0.0129312416667 1 0.0129312516667 0 0.012939995 0 0.012940005 1 0.0129512416667 1 0.0129512516667 0 0.012959995 0 0.012960005 1 0.0129712416667 1
+ 0.0129712516667 0 0.012979995 0 0.012980005 1 0.0129912416667 1 0.0129912516667 0 0.012999995 0 0.013000005 1 0.0130112416667 1 0.0130112516667 0 0.013019995 0 0.013020005 1 0.0130312416667 1 0.0130312516667 0 0.013039995 0 0.013040005 1 0.0130512416667 1
+ 0.0130512516667 0 0.013059995 0 0.013060005 1 0.0130712416667 1 0.0130712516667 0 0.013079995 0 0.013080005 1 0.0130912416667 1 0.0130912516667 0 0.013099995 0 0.013100005 1 0.0131112416667 1 0.0131112516667 0 0.013119995 0 0.013120005 1 0.0131312416667 1
+ 0.0131312516667 0 0.013139995 0 0.013140005 1 0.0131512416667 1 0.0131512516667 0 0.013159995 0 0.013160005 1 0.0131712416667 1 0.0131712516667 0 0.013179995 0 0.013180005 1 0.0131912416667 1 0.0131912516667 0 0.013199995 0 0.013200005 1 0.0132112416667 1
+ 0.0132112516667 0 0.013219995 0 0.013220005 1 0.0132312416667 1 0.0132312516667 0 0.013239995 0 0.013240005 1 0.0132512416667 1 0.0132512516667 0 0.013259995 0 0.013260005 1 0.0132712416667 1 0.0132712516667 0 0.013279995 0 0.013280005 1 0.0132912416667 1
+ 0.0132912516667 0 0.013299995 0 0.013300005 1 0.0133112416667 1 0.0133112516667 0 0.013319995 0 0.013320005 1 0.0133312416667 1 0.0133312516667 0 0.013339995 0 0.013340005 1 0.0133512416667 1 0.0133512516667 0 0.013359995 0 0.013360005 1 0.0133712416667 1
+ 0.0133712516667 0 0.013379995 0 0.013380005 1 0.0133912416667 1 0.0133912516667 0 0.013399995 0 0.013400005 1 0.0134112416667 1 0.0134112516667 0 0.013419995 0 0.013420005 1 0.0134312416667 1 0.0134312516667 0 0.013439995 0 0.013440005 1 0.0134512416667 1
+ 0.0134512516667 0 0.013459995 0 0.013460005 1 0.0134712416667 1 0.0134712516667 0 0.013479995 0 0.013480005 1 0.0134912416667 1 0.0134912516667 0 0.013499995 0 0.013500005 1 0.0135112416667 1 0.0135112516667 0 0.013519995 0 0.013520005 1 0.0135312416667 1
+ 0.0135312516667 0 0.013539995 0 0.013540005 1 0.0135512416667 1 0.0135512516667 0 0.013559995 0 0.013560005 1 0.0135712416667 1 0.0135712516667 0 0.013579995 0 0.013580005 1 0.0135912416667 1 0.0135912516667 0 0.013599995 0 0.013600005 1 0.0136112416667 1
+ 0.0136112516667 0 0.013619995 0 0.013620005 1 0.0136312416667 1 0.0136312516667 0 0.013639995 0 0.013640005 1 0.0136512416667 1 0.0136512516667 0 0.013659995 0 0.013660005 1 0.0136712416667 1 0.0136712516667 0 0.013679995 0 0.013680005 1 0.0136912416667 1
+ 0.0136912516667 0 0.013699995 0 0.013700005 1 0.0137112416667 1 0.0137112516667 0 0.013719995 0 0.013720005 1 0.0137312416667 1 0.0137312516667 0 0.013739995 0 0.013740005 1 0.0137512416667 1 0.0137512516667 0 0.013759995 0 0.013760005 1 0.0137712416667 1
+ 0.0137712516667 0 0.013779995 0 0.013780005 1 0.0137912416667 1 0.0137912516667 0 0.013799995 0 0.013800005 1 0.0138112416667 1 0.0138112516667 0 0.013819995 0 0.013820005 1 0.0138312416667 1 0.0138312516667 0 0.013839995 0 0.013840005 1 0.0138512416667 1
+ 0.0138512516667 0 0.013859995 0 0.013860005 1 0.0138712416667 1 0.0138712516667 0 0.013879995 0 0.013880005 1 0.0138912416667 1 0.0138912516667 0 0.013899995 0 0.013900005 1 0.0139112416667 1 0.0139112516667 0 0.013919995 0 0.013920005 1 0.0139312416667 1
+ 0.0139312516667 0 0.013939995 0 0.013940005 1 0.0139512416667 1 0.0139512516667 0 0.013959995 0 0.013960005 1 0.0139712416667 1 0.0139712516667 0 0.013979995 0 0.013980005 1 0.0139912416667 1 0.0139912516667 0 0.013999995 0 0.014000005 1 0.0140112416667 1
+ 0.0140112516667 0 0.014019995 0 0.014020005 1 0.0140312416667 1 0.0140312516667 0 0.014039995 0 0.014040005 1 0.0140512416667 1 0.0140512516667 0 0.014059995 0 0.014060005 1 0.0140712416667 1 0.0140712516667 0 0.014079995 0 0.014080005 1 0.0140912416667 1
+ 0.0140912516667 0 0.014099995 0 0.014100005 1 0.0141112416667 1 0.0141112516667 0 0.014119995 0 0.014120005 1 0.0141312416667 1 0.0141312516667 0 0.014139995 0 0.014140005 1 0.0141512416667 1 0.0141512516667 0 0.014159995 0 0.014160005 1 0.0141712416667 1
+ 0.0141712516667 0 0.014179995 0 0.014180005 1 0.0141912416667 1 0.0141912516667 0 0.014199995 0 0.014200005 1 0.0142112416667 1 0.0142112516667 0 0.014219995 0 0.014220005 1 0.0142312416667 1 0.0142312516667 0 0.014239995 0 0.014240005 1 0.0142512416667 1
+ 0.0142512516667 0 0.014259995 0 0.014260005 1 0.0142712416667 1 0.0142712516667 0 0.014279995 0 0.014280005 1 0.0142912416667 1 0.0142912516667 0 0.014299995 0 0.014300005 1 0.0143112416667 1 0.0143112516667 0 0.014319995 0 0.014320005 1 0.0143312416667 1
+ 0.0143312516667 0 0.014339995 0 0.014340005 1 0.0143512416667 1 0.0143512516667 0 0.014359995 0 0.014360005 1 0.0143712416667 1 0.0143712516667 0 0.014379995 0 0.014380005 1 0.0143912416667 1 0.0143912516667 0 0.014399995 0 0.014400005 1 0.0144112416667 1
+ 0.0144112516667 0 0.014419995 0 0.014420005 1 0.0144312416667 1 0.0144312516667 0 0.014439995 0 0.014440005 1 0.0144512416667 1 0.0144512516667 0 0.014459995 0 0.014460005 1 0.0144712416667 1 0.0144712516667 0 0.014479995 0 0.014480005 1 0.0144912416667 1
+ 0.0144912516667 0 0.014499995 0 0.014500005 1 0.0145112416667 1 0.0145112516667 0 0.014519995 0 0.014520005 1 0.0145312416667 1 0.0145312516667 0 0.014539995 0 0.014540005 1 0.0145512416667 1 0.0145512516667 0 0.014559995 0 0.014560005 1 0.0145712416667 1
+ 0.0145712516667 0 0.014579995 0 0.014580005 1 0.0145912416667 1 0.0145912516667 0 0.014599995 0 0.014600005 1 0.0146112416667 1 0.0146112516667 0 0.014619995 0 0.014620005 1 0.0146312416667 1 0.0146312516667 0 0.014639995 0 0.014640005 1 0.0146512416667 1
+ 0.0146512516667 0 0.014659995 0 0.014660005 1 0.0146712416667 1 0.0146712516667 0 0.014679995 0 0.014680005 1 0.0146912416667 1 0.0146912516667 0 0.014699995 0 0.014700005 1 0.0147112416667 1 0.0147112516667 0 0.014719995 0 0.014720005 1 0.0147312416667 1
+ 0.0147312516667 0 0.014739995 0 0.014740005 1 0.0147512416667 1 0.0147512516667 0 0.014759995 0 0.014760005 1 0.0147712416667 1 0.0147712516667 0 0.014779995 0 0.014780005 1 0.0147912416667 1 0.0147912516667 0 0.014799995 0 0.014800005 1 0.0148112416667 1
+ 0.0148112516667 0 0.014819995 0 0.014820005 1 0.0148312416667 1 0.0148312516667 0 0.014839995 0 0.014840005 1 0.0148512416667 1 0.0148512516667 0 0.014859995 0 0.014860005 1 0.0148712416667 1 0.0148712516667 0 0.014879995 0 0.014880005 1 0.0148912416667 1
+ 0.0148912516667 0 0.014899995 0 0.014900005 1 0.0149112416667 1 0.0149112516667 0 0.014919995 0 0.014920005 1 0.0149312416667 1 0.0149312516667 0 0.014939995 0 0.014940005 1 0.0149512416667 1 0.0149512516667 0 0.014959995 0 0.014960005 1 0.0149712416667 1
+ 0.0149712516667 0 0.014979995 0 0.014980005 1 0.0149912416667 1 0.0149912516667 0 0.014999995 0 0.015000005 1 0.0150112416667 1 0.0150112516667 0 0.015019995 0 0.015020005 1 0.0150312416667 1 0.0150312516667 0 0.015039995 0 0.015040005 1 0.0150512416667 1
+ 0.0150512516667 0 0.015059995 0 0.015060005 1 0.0150712416667 1 0.0150712516667 0 0.015079995 0 0.015080005 1 0.0150912416667 1 0.0150912516667 0 0.015099995 0 0.015100005 1 0.0151112416667 1 0.0151112516667 0 0.015119995 0 0.015120005 1 0.0151312416667 1
+ 0.0151312516667 0 0.015139995 0 0.015140005 1 0.0151512416667 1 0.0151512516667 0 0.015159995 0 0.015160005 1 0.0151712416667 1 0.0151712516667 0 0.015179995 0 0.015180005 1 0.0151912416667 1 0.0151912516667 0 0.015199995 0 0.015200005 1 0.0152112416667 1
+ 0.0152112516667 0 0.015219995 0 0.015220005 1 0.0152312416667 1 0.0152312516667 0 0.015239995 0 0.015240005 1 0.0152512416667 1 0.0152512516667 0 0.015259995 0 0.015260005 1 0.0152712416667 1 0.0152712516667 0 0.015279995 0 0.015280005 1 0.0152912416667 1
+ 0.0152912516667 0 0.015299995 0 0.015300005 1 0.0153112416667 1 0.0153112516667 0 0.015319995 0 0.015320005 1 0.0153312416667 1 0.0153312516667 0 0.015339995 0 0.015340005 1 0.0153512416667 1 0.0153512516667 0 0.015359995 0 0.015360005 1 0.0153712416667 1
+ 0.0153712516667 0 0.015379995 0 0.015380005 1 0.0153912416667 1 0.0153912516667 0 0.015399995 0 0.015400005 1 0.0154112416667 1 0.0154112516667 0 0.015419995 0 0.015420005 1 0.0154312416667 1 0.0154312516667 0 0.015439995 0 0.015440005 1 0.0154512416667 1
+ 0.0154512516667 0 0.015459995 0 0.015460005 1 0.0154712416667 1 0.0154712516667 0 0.015479995 0 0.015480005 1 0.0154912416667 1 0.0154912516667 0 0.015499995 0 0.015500005 1 0.0155112416667 1 0.0155112516667 0 0.015519995 0 0.015520005 1 0.0155312416667 1
+ 0.0155312516667 0 0.015539995 0 0.015540005 1 0.0155512416667 1 0.0155512516667 0 0.015559995 0 0.015560005 1 0.0155712416667 1 0.0155712516667 0 0.015579995 0 0.015580005 1 0.0155912416667 1 0.0155912516667 0 0.015599995 0 0.015600005 1 0.0156112416667 1
+ 0.0156112516667 0 0.015619995 0 0.015620005 1 0.0156312416667 1 0.0156312516667 0 0.015639995 0 0.015640005 1 0.0156512416667 1 0.0156512516667 0 0.015659995 0 0.015660005 1 0.0156712416667 1 0.0156712516667 0 0.015679995 0 0.015680005 1 0.0156912416667 1
+ 0.0156912516667 0 0.015699995 0 0.015700005 1 0.0157112416667 1 0.0157112516667 0 0.015719995 0 0.015720005 1 0.0157312416667 1 0.0157312516667 0 0.015739995 0 0.015740005 1 0.0157512416667 1 0.0157512516667 0 0.015759995 0 0.015760005 1 0.0157712416667 1
+ 0.0157712516667 0 0.015779995 0 0.015780005 1 0.0157912416667 1 0.0157912516667 0 0.015799995 0 0.015800005 1 0.0158112416667 1 0.0158112516667 0 0.015819995 0 0.015820005 1 0.0158312416667 1 0.0158312516667 0 0.015839995 0 0.015840005 1 0.0158512416667 1
+ 0.0158512516667 0 0.015859995 0 0.015860005 1 0.0158712416667 1 0.0158712516667 0 0.015879995 0 0.015880005 1 0.0158912416667 1 0.0158912516667 0 0.015899995 0 0.015900005 1 0.0159112416667 1 0.0159112516667 0 0.015919995 0 0.015920005 1 0.0159312416667 1
+ 0.0159312516667 0 0.015939995 0 0.015940005 1 0.0159512416667 1 0.0159512516667 0 0.015959995 0 0.015960005 1 0.0159712416667 1 0.0159712516667 0 0.015979995 0 0.015980005 1 0.0159912416667 1 0.0159912516667 0 0.015999995 0 0.016000005 1 0.0160112416667 1
+ 0.0160112516667 0 0.016019995 0 0.016020005 1 0.0160312416667 1 0.0160312516667 0 0.016039995 0 0.016040005 1 0.0160512416667 1 0.0160512516667 0 0.016059995 0 0.016060005 1 0.0160712416667 1 0.0160712516667 0 0.016079995 0 0.016080005 1 0.0160912416667 1
+ 0.0160912516667 0 0.016099995 0 0.016100005 1 0.0161112416667 1 0.0161112516667 0 0.016119995 0 0.016120005 1 0.0161312416667 1 0.0161312516667 0 0.016139995 0 0.016140005 1 0.0161512416667 1 0.0161512516667 0 0.016159995 0 0.016160005 1 0.0161712416667 1
+ 0.0161712516667 0 0.016179995 0 0.016180005 1 0.0161912416667 1 0.0161912516667 0 0.016199995 0 0.016200005 1 0.0162112416667 1 0.0162112516667 0 0.016219995 0 0.016220005 1 0.0162312416667 1 0.0162312516667 0 0.016239995 0 0.016240005 1 0.0162512416667 1
+ 0.0162512516667 0 0.016259995 0 0.016260005 1 0.0162712416667 1 0.0162712516667 0 0.016279995 0 0.016280005 1 0.0162912416667 1 0.0162912516667 0 0.016299995 0 0.016300005 1 0.0163112416667 1 0.0163112516667 0 0.016319995 0 0.016320005 1 0.0163312416667 1
+ 0.0163312516667 0 0.016339995 0 0.016340005 1 0.0163512416667 1 0.0163512516667 0 0.016359995 0 0.016360005 1 0.0163712416667 1 0.0163712516667 0 0.016379995 0 0.016380005 1 0.0163912416667 1 0.0163912516667 0 0.016399995 0 0.016400005 1 0.0164112416667 1
+ 0.0164112516667 0 0.016419995 0 0.016420005 1 0.0164312416667 1 0.0164312516667 0 0.016439995 0 0.016440005 1 0.0164512416667 1 0.0164512516667 0 0.016459995 0 0.016460005 1 0.0164712416667 1 0.0164712516667 0 0.016479995 0 0.016480005 1 0.0164912416667 1
+ 0.0164912516667 0 0.016499995 0 0.016500005 1 0.0165112416667 1 0.0165112516667 0 0.016519995 0 0.016520005 1 0.0165312416667 1 0.0165312516667 0 0.016539995 0 0.016540005 1 0.0165512416667 1 0.0165512516667 0 0.016559995 0 0.016560005 1 0.0165712416667 1
+ 0.0165712516667 0 0.016579995 0 0.016580005 1 0.0165912416667 1 0.0165912516667 0 0.016599995 0 0.016600005 1 0.0166112416667 1 0.0166112516667 0 0.016619995 0 0.016620005 1 0.0166312416667 1 0.0166312516667 0 0.016639995 0 0.016640005 1 0.0166512416667 1
+ 0.0166512516667 0 0.016659995 0 0.016660005 1 0.0166712416667 1 0.0166712516667 0 0.016679995 0 0.016680005 1 0.0166912416667 1 0.0166912516667 0 0.016699995 0 0.016700005 1 0.0167112416667 1 0.0167112516667 0 0.016719995 0 0.016720005 1 0.0167312416667 1
+ 0.0167312516667 0 0.016739995 0 0.016740005 1 0.0167512416667 1 0.0167512516667 0 0.016759995 0 0.016760005 1 0.0167712416667 1 0.0167712516667 0 0.016779995 0 0.016780005 1 0.0167912416667 1 0.0167912516667 0 0.016799995 0 0.016800005 1 0.0168112416667 1
+ 0.0168112516667 0 0.016819995 0 0.016820005 1 0.0168312416667 1 0.0168312516667 0 0.016839995 0 0.016840005 1 0.0168512416667 1 0.0168512516667 0 0.016859995 0 0.016860005 1 0.0168712416667 1 0.0168712516667 0 0.016879995 0 0.016880005 1 0.0168912416667 1
+ 0.0168912516667 0 0.016899995 0 0.016900005 1 0.0169112416667 1 0.0169112516667 0 0.016919995 0 0.016920005 1 0.0169312416667 1 0.0169312516667 0 0.016939995 0 0.016940005 1 0.0169512416667 1 0.0169512516667 0 0.016959995 0 0.016960005 1 0.0169712416667 1
+ 0.0169712516667 0 0.016979995 0 0.016980005 1 0.0169912416667 1 0.0169912516667 0 0.016999995 0 0.017000005 1 0.0170112416667 1 0.0170112516667 0 0.017019995 0 0.017020005 1 0.0170312416667 1 0.0170312516667 0 0.017039995 0 0.017040005 1 0.0170512416667 1
+ 0.0170512516667 0 0.017059995 0 0.017060005 1 0.0170712416667 1 0.0170712516667 0 0.017079995 0 0.017080005 1 0.0170912416667 1 0.0170912516667 0 0.017099995 0 0.017100005 1 0.0171112416667 1 0.0171112516667 0 0.017119995 0 0.017120005 1 0.0171312416667 1
+ 0.0171312516667 0 0.017139995 0 0.017140005 1 0.0171512416667 1 0.0171512516667 0 0.017159995 0 0.017160005 1 0.0171712416667 1 0.0171712516667 0 0.017179995 0 0.017180005 1 0.0171912416667 1 0.0171912516667 0 0.017199995 0 0.017200005 1 0.0172112416667 1
+ 0.0172112516667 0 0.017219995 0 0.017220005 1 0.0172312416667 1 0.0172312516667 0 0.017239995 0 0.017240005 1 0.0172512416667 1 0.0172512516667 0 0.017259995 0 0.017260005 1 0.0172712416667 1 0.0172712516667 0 0.017279995 0 0.017280005 1 0.0172912416667 1
+ 0.0172912516667 0 0.017299995 0 0.017300005 1 0.0173112416667 1 0.0173112516667 0 0.017319995 0 0.017320005 1 0.0173312416667 1 0.0173312516667 0 0.017339995 0 0.017340005 1 0.0173512416667 1 0.0173512516667 0 0.017359995 0 0.017360005 1 0.0173712416667 1
+ 0.0173712516667 0 0.017379995 0 0.017380005 1 0.0173912416667 1 0.0173912516667 0 0.017399995 0 0.017400005 1 0.0174112416667 1 0.0174112516667 0 0.017419995 0 0.017420005 1 0.0174312416667 1 0.0174312516667 0 0.017439995 0 0.017440005 1 0.0174512416667 1
+ 0.0174512516667 0 0.017459995 0 0.017460005 1 0.0174712416667 1 0.0174712516667 0 0.017479995 0 0.017480005 1 0.0174912416667 1 0.0174912516667 0 0.017499995 0 0.017500005 1 0.0175112416667 1 0.0175112516667 0 0.017519995 0 0.017520005 1 0.0175312416667 1
+ 0.0175312516667 0 0.017539995 0 0.017540005 1 0.0175512416667 1 0.0175512516667 0 0.017559995 0 0.017560005 1 0.0175712416667 1 0.0175712516667 0 0.017579995 0 0.017580005 1 0.0175912416667 1 0.0175912516667 0 0.017599995 0 0.017600005 1 0.0176112416667 1
+ 0.0176112516667 0 0.017619995 0 0.017620005 1 0.0176312416667 1 0.0176312516667 0 0.017639995 0 0.017640005 1 0.0176512416667 1 0.0176512516667 0 0.017659995 0 0.017660005 1 0.0176712416667 1 0.0176712516667 0 0.017679995 0 0.017680005 1 0.0176912416667 1
+ 0.0176912516667 0 0.017699995 0 0.017700005 1 0.0177112416667 1 0.0177112516667 0 0.017719995 0 0.017720005 1 0.0177312416667 1 0.0177312516667 0 0.017739995 0 0.017740005 1 0.0177512416667 1 0.0177512516667 0 0.017759995 0 0.017760005 1 0.0177712416667 1
+ 0.0177712516667 0 0.017779995 0 0.017780005 1 0.0177912416667 1 0.0177912516667 0 0.017799995 0 0.017800005 1 0.0178112416667 1 0.0178112516667 0 0.017819995 0 0.017820005 1 0.0178312416667 1 0.0178312516667 0 0.017839995 0 0.017840005 1 0.0178512416667 1
+ 0.0178512516667 0 0.017859995 0 0.017860005 1 0.0178712416667 1 0.0178712516667 0 0.017879995 0 0.017880005 1 0.0178912416667 1 0.0178912516667 0 0.017899995 0 0.017900005 1 0.0179112416667 1 0.0179112516667 0 0.017919995 0 0.017920005 1 0.0179312416667 1
+ 0.0179312516667 0 0.017939995 0 0.017940005 1 0.0179512416667 1 0.0179512516667 0 0.017959995 0 0.017960005 1 0.0179712416667 1 0.0179712516667 0 0.017979995 0 0.017980005 1 0.0179912416667 1 0.0179912516667 0 0.017999995 0 0.018000005 1 0.0180112416667 1
+ 0.0180112516667 0 0.018019995 0 0.018020005 1 0.0180312416667 1 0.0180312516667 0 0.018039995 0 0.018040005 1 0.0180512416667 1 0.0180512516667 0 0.018059995 0 0.018060005 1 0.0180712416667 1 0.0180712516667 0 0.018079995 0 0.018080005 1 0.0180912416667 1
+ 0.0180912516667 0 0.018099995 0 0.018100005 1 0.0181112416667 1 0.0181112516667 0 0.018119995 0 0.018120005 1 0.0181312416667 1 0.0181312516667 0 0.018139995 0 0.018140005 1 0.0181512416667 1 0.0181512516667 0 0.018159995 0 0.018160005 1 0.0181712416667 1
+ 0.0181712516667 0 0.018179995 0 0.018180005 1 0.0181912416667 1 0.0181912516667 0 0.018199995 0 0.018200005 1 0.0182112416667 1 0.0182112516667 0 0.018219995 0 0.018220005 1 0.0182312416667 1 0.0182312516667 0 0.018239995 0 0.018240005 1 0.0182512416667 1
+ 0.0182512516667 0 0.018259995 0 0.018260005 1 0.0182712416667 1 0.0182712516667 0 0.018279995 0 0.018280005 1 0.0182912416667 1 0.0182912516667 0 0.018299995 0 0.018300005 1 0.0183112416667 1 0.0183112516667 0 0.018319995 0 0.018320005 1 0.0183312416667 1
+ 0.0183312516667 0 0.018339995 0 0.018340005 1 0.0183512416667 1 0.0183512516667 0 0.018359995 0 0.018360005 1 0.0183712416667 1 0.0183712516667 0 0.018379995 0 0.018380005 1 0.0183912416667 1 0.0183912516667 0 0.018399995 0 0.018400005 1 0.0184112416667 1
+ 0.0184112516667 0 0.018419995 0 0.018420005 1 0.0184312416667 1 0.0184312516667 0 0.018439995 0 0.018440005 1 0.0184512416667 1 0.0184512516667 0 0.018459995 0 0.018460005 1 0.0184712416667 1 0.0184712516667 0 0.018479995 0 0.018480005 1 0.0184912416667 1
+ 0.0184912516667 0 0.018499995 0 0.018500005 1 0.0185112416667 1 0.0185112516667 0 0.018519995 0 0.018520005 1 0.0185312416667 1 0.0185312516667 0 0.018539995 0 0.018540005 1 0.0185512416667 1 0.0185512516667 0 0.018559995 0 0.018560005 1 0.0185712416667 1
+ 0.0185712516667 0 0.018579995 0 0.018580005 1 0.0185912416667 1 0.0185912516667 0 0.018599995 0 0.018600005 1 0.0186112416667 1 0.0186112516667 0 0.018619995 0 0.018620005 1 0.0186312416667 1 0.0186312516667 0 0.018639995 0 0.018640005 1 0.0186512416667 1
+ 0.0186512516667 0 0.018659995 0 0.018660005 1 0.0186712416667 1 0.0186712516667 0 0.018679995 0 0.018680005 1 0.0186912416667 1 0.0186912516667 0 0.018699995 0 0.018700005 1 0.0187112416667 1 0.0187112516667 0 0.018719995 0 0.018720005 1 0.0187312416667 1
+ 0.0187312516667 0 0.018739995 0 0.018740005 1 0.0187512416667 1 0.0187512516667 0 0.018759995 0 0.018760005 1 0.0187712416667 1 0.0187712516667 0 0.018779995 0 0.018780005 1 0.0187912416667 1 0.0187912516667 0 0.018799995 0 0.018800005 1 0.0188112416667 1
+ 0.0188112516667 0 0.018819995 0 0.018820005 1 0.0188312416667 1 0.0188312516667 0 0.018839995 0 0.018840005 1 0.0188512416667 1 0.0188512516667 0 0.018859995 0 0.018860005 1 0.0188712416667 1 0.0188712516667 0 0.018879995 0 0.018880005 1 0.0188912416667 1
+ 0.0188912516667 0 0.018899995 0 0.018900005 1 0.0189112416667 1 0.0189112516667 0 0.018919995 0 0.018920005 1 0.0189312416667 1 0.0189312516667 0 0.018939995 0 0.018940005 1 0.0189512416667 1 0.0189512516667 0 0.018959995 0 0.018960005 1 0.0189712416667 1
+ 0.0189712516667 0 0.018979995 0 0.018980005 1 0.0189912416667 1 0.0189912516667 0 0.018999995 0 0.019000005 1 0.0190112416667 1 0.0190112516667 0 0.019019995 0 0.019020005 1 0.0190312416667 1 0.0190312516667 0 0.019039995 0 0.019040005 1 0.0190512416667 1
+ 0.0190512516667 0 0.019059995 0 0.019060005 1 0.0190712416667 1 0.0190712516667 0 0.019079995 0 0.019080005 1 0.0190912416667 1 0.0190912516667 0 0.019099995 0 0.019100005 1 0.0191112416667 1 0.0191112516667 0 0.019119995 0 0.019120005 1 0.0191312416667 1
+ 0.0191312516667 0 0.019139995 0 0.019140005 1 0.0191512416667 1 0.0191512516667 0 0.019159995 0 0.019160005 1 0.0191712416667 1 0.0191712516667 0 0.019179995 0 0.019180005 1 0.0191912416667 1 0.0191912516667 0 0.019199995 0 0.019200005 1 0.0192112416667 1
+ 0.0192112516667 0 0.019219995 0 0.019220005 1 0.0192312416667 1 0.0192312516667 0 0.019239995 0 0.019240005 1 0.0192512416667 1 0.0192512516667 0 0.019259995 0 0.019260005 1 0.0192712416667 1 0.0192712516667 0 0.019279995 0 0.019280005 1 0.0192912416667 1
+ 0.0192912516667 0 0.019299995 0 0.019300005 1 0.0193112416667 1 0.0193112516667 0 0.019319995 0 0.019320005 1 0.0193312416667 1 0.0193312516667 0 0.019339995 0 0.019340005 1 0.0193512416667 1 0.0193512516667 0 0.019359995 0 0.019360005 1 0.0193712416667 1
+ 0.0193712516667 0 0.019379995 0 0.019380005 1 0.0193912416667 1 0.0193912516667 0 0.019399995 0 0.019400005 1 0.0194112416667 1 0.0194112516667 0 0.019419995 0 0.019420005 1 0.0194312416667 1 0.0194312516667 0 0.019439995 0 0.019440005 1 0.0194512416667 1
+ 0.0194512516667 0 0.019459995 0 0.019460005 1 0.0194712416667 1 0.0194712516667 0 0.019479995 0 0.019480005 1 0.0194912416667 1 0.0194912516667 0 0.019499995 0 0.019500005 1 0.0195112416667 1 0.0195112516667 0 0.019519995 0 0.019520005 1 0.0195312416667 1
+ 0.0195312516667 0 0.019539995 0 0.019540005 1 0.0195512416667 1 0.0195512516667 0 0.019559995 0 0.019560005 1 0.0195712416667 1 0.0195712516667 0 0.019579995 0 0.019580005 1 0.0195912416667 1 0.0195912516667 0 0.019599995 0 0.019600005 1 0.0196112416667 1
+ 0.0196112516667 0 0.019619995 0 0.019620005 1 0.0196312416667 1 0.0196312516667 0 0.019639995 0 0.019640005 1 0.0196512416667 1 0.0196512516667 0 0.019659995 0 0.019660005 1 0.0196712416667 1 0.0196712516667 0 0.019679995 0 0.019680005 1 0.0196912416667 1
+ 0.0196912516667 0 0.019699995 0 0.019700005 1 0.0197112416667 1 0.0197112516667 0 0.019719995 0 0.019720005 1 0.0197312416667 1 0.0197312516667 0 0.019739995 0 0.019740005 1 0.0197512416667 1 0.0197512516667 0 0.019759995 0 0.019760005 1 0.0197712416667 1
+ 0.0197712516667 0 0.019779995 0 0.019780005 1 0.0197912416667 1 0.0197912516667 0 0.019799995 0 0.019800005 1 0.0198112416667 1 0.0198112516667 0 0.019819995 0 0.019820005 1 0.0198312416667 1 0.0198312516667 0 0.019839995 0 0.019840005 1 0.0198512416667 1
+ 0.0198512516667 0 0.019859995 0 0.019860005 1 0.0198712416667 1 0.0198712516667 0 0.019879995 0 0.019880005 1 0.0198912416667 1 0.0198912516667 0 0.019899995 0 0.019900005 1 0.0199112416667 1 0.0199112516667 0 0.019919995 0 0.019920005 1 0.0199312416667 1
+ 0.0199312516667 0 0.019939995 0 0.019940005 1 0.0199512416667 1 0.0199512516667 0 0.019959995 0 0.019960005 1 0.0199712416667 1 0.0199712516667 0 0.019979995 0 0.019980005 1 0.0199912416667 1 0.0199912516667 0 0.019999995 0 0.020000005 1 0.0200112416667 1
+ 0.0200112516667 0 0.020019995 0 0.020020005 1 0.0200312416667 1 0.0200312516667 0 0.020039995 0 0.020040005 1 0.0200512416667 1 0.0200512516667 0 0.020059995 0 0.020060005 1 0.0200712416667 1 0.0200712516667 0 0.020079995 0 0.020080005 1 0.0200912416667 1
+ 0.0200912516667 0 0.020099995 0 0.020100005 1 0.0201112416667 1 0.0201112516667 0 0.020119995 0 0.020120005 1 0.0201312416667 1 0.0201312516667 0 0.020139995 0 0.020140005 1 0.0201512416667 1 0.0201512516667 0 0.020159995 0 0.020160005 1 0.0201712416667 1
+ 0.0201712516667 0 0.020179995 0 0.020180005 1 0.0201912416667 1 0.0201912516667 0 0.020199995 0 0.020200005 1 0.0202112416667 1 0.0202112516667 0 0.020219995 0 0.020220005 1 0.0202312416667 1 0.0202312516667 0 0.020239995 0 0.020240005 1 0.0202512416667 1
+ 0.0202512516667 0 0.020259995 0 0.020260005 1 0.0202712416667 1 0.0202712516667 0 0.020279995 0 0.020280005 1 0.0202912416667 1 0.0202912516667 0 0.020299995 0 0.020300005 1 0.0203112416667 1 0.0203112516667 0 0.020319995 0 0.020320005 1 0.0203312416667 1
+ 0.0203312516667 0 0.020339995 0 0.020340005 1 0.0203512416667 1 0.0203512516667 0 0.020359995 0 0.020360005 1 0.0203712416667 1 0.0203712516667 0 0.020379995 0 0.020380005 1 0.0203912416667 1 0.0203912516667 0 0.020399995 0 0.020400005 1 0.0204112416667 1
+ 0.0204112516667 0 0.020419995 0 0.020420005 1 0.0204312416667 1 0.0204312516667 0 0.020439995 0 0.020440005 1 0.0204512416667 1 0.0204512516667 0 0.020459995 0 0.020460005 1 0.0204712416667 1 0.0204712516667 0 0.020479995 0 0.020480005 1 0.0204912416667 1
+ 0.0204912516667 0 0.020499995 0 0.020500005 1 0.0205112416667 1 0.0205112516667 0 0.020519995 0 0.020520005 1 0.0205312416667 1 0.0205312516667 0 0.020539995 0 0.020540005 1 0.0205512416667 1 0.0205512516667 0 0.020559995 0 0.020560005 1 0.0205712416667 1
+ 0.0205712516667 0 0.020579995 0 0.020580005 1 0.0205912416667 1 0.0205912516667 0 0.020599995 0 0.020600005 1 0.0206112416667 1 0.0206112516667 0 0.020619995 0 0.020620005 1 0.0206312416667 1 0.0206312516667 0 0.020639995 0 0.020640005 1 0.0206512416667 1
+ 0.0206512516667 0 0.020659995 0 0.020660005 1 0.0206712416667 1 0.0206712516667 0 0.020679995 0 0.020680005 1 0.0206912416667 1 0.0206912516667 0 0.020699995 0 0.020700005 1 0.0207112416667 1 0.0207112516667 0 0.020719995 0 0.020720005 1 0.0207312416667 1
+ 0.0207312516667 0 0.020739995 0 0.020740005 1 0.0207512416667 1 0.0207512516667 0 0.020759995 0 0.020760005 1 0.0207712416667 1 0.0207712516667 0 0.020779995 0 0.020780005 1 0.0207912416667 1 0.0207912516667 0 0.020799995 0 0.020800005 1 0.0208112416667 1
+ 0.0208112516667 0 0.020819995 0 0.020820005 1 0.0208312416667 1 0.0208312516667 0 0.020839995 0 0.020840005 1 0.0208512416667 1 0.0208512516667 0 0.020859995 0 0.020860005 1 0.0208712416667 1 0.0208712516667 0 0.020879995 0 0.020880005 1 0.0208912416667 1
+ 0.0208912516667 0 0.020899995 0 0.020900005 1 0.0209112416667 1 0.0209112516667 0 0.020919995 0 0.020920005 1 0.0209312416667 1 0.0209312516667 0 0.020939995 0 0.020940005 1 0.0209512416667 1 0.0209512516667 0 0.020959995 0 0.020960005 1 0.0209712416667 1
+ 0.0209712516667 0 0.020979995 0 0.020980005 1 0.0209912416667 1 0.0209912516667 0 0.020999995 0 0.021000005 1 0.0210112416667 1 0.0210112516667 0 0.021019995 0 0.021020005 1 0.0210312416667 1 0.0210312516667 0 0.021039995 0 0.021040005 1 0.0210512416667 1
+ 0.0210512516667 0 0.021059995 0 0.021060005 1 0.0210712416667 1 0.0210712516667 0 0.021079995 0 0.021080005 1 0.0210912416667 1 0.0210912516667 0 0.021099995 0 0.021100005 1 0.0211112416667 1 0.0211112516667 0 0.021119995 0 0.021120005 1 0.0211312416667 1
+ 0.0211312516667 0 0.021139995 0 0.021140005 1 0.0211512416667 1 0.0211512516667 0 0.021159995 0 0.021160005 1 0.0211712416667 1 0.0211712516667 0 0.021179995 0 0.021180005 1 0.0211912416667 1 0.0211912516667 0 0.021199995 0 0.021200005 1 0.0212112416667 1
+ 0.0212112516667 0 0.021219995 0 0.021220005 1 0.0212312416667 1 0.0212312516667 0 0.021239995 0 0.021240005 1 0.0212512416667 1 0.0212512516667 0 0.021259995 0 0.021260005 1 0.0212712416667 1 0.0212712516667 0 0.021279995 0 0.021280005 1 0.0212912416667 1
+ 0.0212912516667 0 0.021299995 0 0.021300005 1 0.0213112416667 1 0.0213112516667 0 0.021319995 0 0.021320005 1 0.0213312416667 1 0.0213312516667 0 0.021339995 0 0.021340005 1 0.0213512416667 1 0.0213512516667 0 0.021359995 0 0.021360005 1 0.0213712416667 1
+ 0.0213712516667 0 0.021379995 0 0.021380005 1 0.0213912416667 1 0.0213912516667 0 0.021399995 0 0.021400005 1 0.0214112416667 1 0.0214112516667 0 0.021419995 0 0.021420005 1 0.0214312416667 1 0.0214312516667 0 0.021439995 0 0.021440005 1 0.0214512416667 1
+ 0.0214512516667 0 0.021459995 0 0.021460005 1 0.0214712416667 1 0.0214712516667 0 0.021479995 0 0.021480005 1 0.0214912416667 1 0.0214912516667 0 0.021499995 0 0.021500005 1 0.0215112416667 1 0.0215112516667 0 0.021519995 0 0.021520005 1 0.0215312416667 1
+ 0.0215312516667 0 0.021539995 0 0.021540005 1 0.0215512416667 1 0.0215512516667 0 0.021559995 0 0.021560005 1 0.0215712416667 1 0.0215712516667 0 0.021579995 0 0.021580005 1 0.0215912416667 1 0.0215912516667 0 0.021599995 0 0.021600005 1 0.0216112416667 1
+ 0.0216112516667 0 0.021619995 0 0.021620005 1 0.0216312416667 1 0.0216312516667 0 0.021639995 0 0.021640005 1 0.0216512416667 1 0.0216512516667 0 0.021659995 0 0.021660005 1 0.0216712416667 1 0.0216712516667 0 0.021679995 0 0.021680005 1 0.0216912416667 1
+ 0.0216912516667 0 0.021699995 0 0.021700005 1 0.0217112416667 1 0.0217112516667 0 0.021719995 0 0.021720005 1 0.0217312416667 1 0.0217312516667 0 0.021739995 0 0.021740005 1 0.0217512416667 1 0.0217512516667 0 0.021759995 0 0.021760005 1 0.0217712416667 1
+ 0.0217712516667 0 0.021779995 0 0.021780005 1 0.0217912416667 1 0.0217912516667 0 0.021799995 0 0.021800005 1 0.0218112416667 1 0.0218112516667 0 0.021819995 0 0.021820005 1 0.0218312416667 1 0.0218312516667 0 0.021839995 0 0.021840005 1 0.0218512416667 1
+ 0.0218512516667 0 0.021859995 0 0.021860005 1 0.0218712416667 1 0.0218712516667 0 0.021879995 0 0.021880005 1 0.0218912416667 1 0.0218912516667 0 0.021899995 0 0.021900005 1 0.0219112416667 1 0.0219112516667 0 0.021919995 0 0.021920005 1 0.0219312416667 1
+ 0.0219312516667 0 0.021939995 0 0.021940005 1 0.0219512416667 1 0.0219512516667 0 0.021959995 0 0.021960005 1 0.0219712416667 1 0.0219712516667 0 0.021979995 0 0.021980005 1 0.0219912416667 1 0.0219912516667 0 0.021999995 0 0.022000005 1 0.0220112416667 1
+ 0.0220112516667 0 0.022019995 0 0.022020005 1 0.0220312416667 1 0.0220312516667 0 0.022039995 0 0.022040005 1 0.0220512416667 1 0.0220512516667 0 0.022059995 0 0.022060005 1 0.0220712416667 1 0.0220712516667 0 0.022079995 0 0.022080005 1 0.0220912416667 1
+ 0.0220912516667 0 0.022099995 0 0.022100005 1 0.0221112416667 1 0.0221112516667 0 0.022119995 0 0.022120005 1 0.0221312416667 1 0.0221312516667 0 0.022139995 0 0.022140005 1 0.0221512416667 1 0.0221512516667 0 0.022159995 0 0.022160005 1 0.0221712416667 1
+ 0.0221712516667 0 0.022179995 0 0.022180005 1 0.0221912416667 1 0.0221912516667 0 0.022199995 0 0.022200005 1 0.0222112416667 1 0.0222112516667 0 0.022219995 0 0.022220005 1 0.0222312416667 1 0.0222312516667 0 0.022239995 0 0.022240005 1 0.0222512416667 1
+ 0.0222512516667 0 0.022259995 0 0.022260005 1 0.0222712416667 1 0.0222712516667 0 0.022279995 0 0.022280005 1 0.0222912416667 1 0.0222912516667 0 0.022299995 0 0.022300005 1 0.0223112416667 1 0.0223112516667 0 0.022319995 0 0.022320005 1 0.0223312416667 1
+ 0.0223312516667 0 0.022339995 0 0.022340005 1 0.0223512416667 1 0.0223512516667 0 0.022359995 0 0.022360005 1 0.0223712416667 1 0.0223712516667 0 0.022379995 0 0.022380005 1 0.0223912416667 1 0.0223912516667 0 0.022399995 0 0.022400005 1 0.0224112416667 1
+ 0.0224112516667 0 0.022419995 0 0.022420005 1 0.0224312416667 1 0.0224312516667 0 0.022439995 0 0.022440005 1 0.0224512416667 1 0.0224512516667 0 0.022459995 0 0.022460005 1 0.0224712416667 1 0.0224712516667 0 0.022479995 0 0.022480005 1 0.0224912416667 1
+ 0.0224912516667 0 0.022499995 0 0.022500005 1 0.0225112416667 1 0.0225112516667 0 0.022519995 0 0.022520005 1 0.0225312416667 1 0.0225312516667 0 0.022539995 0 0.022540005 1 0.0225512416667 1 0.0225512516667 0 0.022559995 0 0.022560005 1 0.0225712416667 1
+ 0.0225712516667 0 0.022579995 0 0.022580005 1 0.0225912416667 1 0.0225912516667 0 0.022599995 0 0.022600005 1 0.0226112416667 1 0.0226112516667 0 0.022619995 0 0.022620005 1 0.0226312416667 1 0.0226312516667 0 0.022639995 0 0.022640005 1 0.0226512416667 1
+ 0.0226512516667 0 0.022659995 0 0.022660005 1 0.0226712416667 1 0.0226712516667 0 0.022679995 0 0.022680005 1 0.0226912416667 1 0.0226912516667 0 0.022699995 0 0.022700005 1 0.0227112416667 1 0.0227112516667 0 0.022719995 0 0.022720005 1 0.0227312416667 1
+ 0.0227312516667 0 0.022739995 0 0.022740005 1 0.0227512416667 1 0.0227512516667 0 0.022759995 0 0.022760005 1 0.0227712416667 1 0.0227712516667 0 0.022779995 0 0.022780005 1 0.0227912416667 1 0.0227912516667 0 0.022799995 0 0.022800005 1 0.0228112416667 1
+ 0.0228112516667 0 0.022819995 0 0.022820005 1 0.0228312416667 1 0.0228312516667 0 0.022839995 0 0.022840005 1 0.0228512416667 1 0.0228512516667 0 0.022859995 0 0.022860005 1 0.0228712416667 1 0.0228712516667 0 0.022879995 0 0.022880005 1 0.0228912416667 1
+ 0.0228912516667 0 0.022899995 0 0.022900005 1 0.0229112416667 1 0.0229112516667 0 0.022919995 0 0.022920005 1 0.0229312416667 1 0.0229312516667 0 0.022939995 0 0.022940005 1 0.0229512416667 1 0.0229512516667 0 0.022959995 0 0.022960005 1 0.0229712416667 1
+ 0.0229712516667 0 0.022979995 0 0.022980005 1 0.0229912416667 1 0.0229912516667 0 0.022999995 0 0.023000005 1 0.0230112416667 1 0.0230112516667 0 0.023019995 0 0.023020005 1 0.0230312416667 1 0.0230312516667 0 0.023039995 0 0.023040005 1 0.0230512416667 1
+ 0.0230512516667 0 0.023059995 0 0.023060005 1 0.0230712416667 1 0.0230712516667 0 0.023079995 0 0.023080005 1 0.0230912416667 1 0.0230912516667 0 0.023099995 0 0.023100005 1 0.0231112416667 1 0.0231112516667 0 0.023119995 0 0.023120005 1 0.0231312416667 1
+ 0.0231312516667 0 0.023139995 0 0.023140005 1 0.0231512416667 1 0.0231512516667 0 0.023159995 0 0.023160005 1 0.0231712416667 1 0.0231712516667 0 0.023179995 0 0.023180005 1 0.0231912416667 1 0.0231912516667 0 0.023199995 0 0.023200005 1 0.0232112416667 1
+ 0.0232112516667 0 0.023219995 0 0.023220005 1 0.0232312416667 1 0.0232312516667 0 0.023239995 0 0.023240005 1 0.0232512416667 1 0.0232512516667 0 0.023259995 0 0.023260005 1 0.0232712416667 1 0.0232712516667 0 0.023279995 0 0.023280005 1 0.0232912416667 1
+ 0.0232912516667 0 0.023299995 0 0.023300005 1 0.0233112416667 1 0.0233112516667 0 0.023319995 0 0.023320005 1 0.0233312416667 1 0.0233312516667 0 0.023339995 0 0.023340005 1 0.0233512416667 1 0.0233512516667 0 0.023359995 0 0.023360005 1 0.0233712416667 1
+ 0.0233712516667 0 0.023379995 0 0.023380005 1 0.0233912416667 1 0.0233912516667 0 0.023399995 0 0.023400005 1 0.0234112416667 1 0.0234112516667 0 0.023419995 0 0.023420005 1 0.0234312416667 1 0.0234312516667 0 0.023439995 0 0.023440005 1 0.0234512416667 1
+ 0.0234512516667 0 0.023459995 0 0.023460005 1 0.0234712416667 1 0.0234712516667 0 0.023479995 0 0.023480005 1 0.0234912416667 1 0.0234912516667 0 0.023499995 0 0.023500005 1 0.0235112416667 1 0.0235112516667 0 0.023519995 0 0.023520005 1 0.0235312416667 1
+ 0.0235312516667 0 0.023539995 0 0.023540005 1 0.0235512416667 1 0.0235512516667 0 0.023559995 0 0.023560005 1 0.0235712416667 1 0.0235712516667 0 0.023579995 0 0.023580005 1 0.0235912416667 1 0.0235912516667 0 0.023599995 0 0.023600005 1 0.0236112416667 1
+ 0.0236112516667 0 0.023619995 0 0.023620005 1 0.0236312416667 1 0.0236312516667 0 0.023639995 0 0.023640005 1 0.0236512416667 1 0.0236512516667 0 0.023659995 0 0.023660005 1 0.0236712416667 1 0.0236712516667 0 0.023679995 0 0.023680005 1 0.0236912416667 1
+ 0.0236912516667 0 0.023699995 0 0.023700005 1 0.0237112416667 1 0.0237112516667 0 0.023719995 0 0.023720005 1 0.0237312416667 1 0.0237312516667 0 0.023739995 0 0.023740005 1 0.0237512416667 1 0.0237512516667 0 0.023759995 0 0.023760005 1 0.0237712416667 1
+ 0.0237712516667 0 0.023779995 0 0.023780005 1 0.0237912416667 1 0.0237912516667 0 0.023799995 0 0.023800005 1 0.0238112416667 1 0.0238112516667 0 0.023819995 0 0.023820005 1 0.0238312416667 1 0.0238312516667 0 0.023839995 0 0.023840005 1 0.0238512416667 1
+ 0.0238512516667 0 0.023859995 0 0.023860005 1 0.0238712416667 1 0.0238712516667 0 0.023879995 0 0.023880005 1 0.0238912416667 1 0.0238912516667 0 0.023899995 0 0.023900005 1 0.0239112416667 1 0.0239112516667 0 0.023919995 0 0.023920005 1 0.0239312416667 1
+ 0.0239312516667 0 0.023939995 0 0.023940005 1 0.0239512416667 1 0.0239512516667 0 0.023959995 0 0.023960005 1 0.0239712416667 1 0.0239712516667 0 0.023979995 0 0.023980005 1 0.0239912416667 1 0.0239912516667 0 0.023999995 0 0.024000005 1 0.0240112416667 1
+ 0.0240112516667 0 0.024019995 0 0.024020005 1 0.0240312416667 1 0.0240312516667 0 0.024039995 0 0.024040005 1 0.0240512416667 1 0.0240512516667 0 0.024059995 0 0.024060005 1 0.0240712416667 1 0.0240712516667 0 0.024079995 0 0.024080005 1 0.0240912416667 1
+ 0.0240912516667 0 0.024099995 0 0.024100005 1 0.0241112416667 1 0.0241112516667 0 0.024119995 0 0.024120005 1 0.0241312416667 1 0.0241312516667 0 0.024139995 0 0.024140005 1 0.0241512416667 1 0.0241512516667 0 0.024159995 0 0.024160005 1 0.0241712416667 1
+ 0.0241712516667 0 0.024179995 0 0.024180005 1 0.0241912416667 1 0.0241912516667 0 0.024199995 0 0.024200005 1 0.0242112416667 1 0.0242112516667 0 0.024219995 0 0.024220005 1 0.0242312416667 1 0.0242312516667 0 0.024239995 0 0.024240005 1 0.0242512416667 1
+ 0.0242512516667 0 0.024259995 0 0.024260005 1 0.0242712416667 1 0.0242712516667 0 0.024279995 0 0.024280005 1 0.0242912416667 1 0.0242912516667 0 0.024299995 0 0.024300005 1 0.0243112416667 1 0.0243112516667 0 0.024319995 0 0.024320005 1 0.0243312416667 1
+ 0.0243312516667 0 0.024339995 0 0.024340005 1 0.0243512416667 1 0.0243512516667 0 0.024359995 0 0.024360005 1 0.0243712416667 1 0.0243712516667 0 0.024379995 0 0.024380005 1 0.0243912416667 1 0.0243912516667 0 0.024399995 0 0.024400005 1 0.0244112416667 1
+ 0.0244112516667 0 0.024419995 0 0.024420005 1 0.0244312416667 1 0.0244312516667 0 0.024439995 0 0.024440005 1 0.0244512416667 1 0.0244512516667 0 0.024459995 0 0.024460005 1 0.0244712416667 1 0.0244712516667 0 0.024479995 0 0.024480005 1 0.0244912416667 1
+ 0.0244912516667 0 0.024499995 0 0.024500005 1 0.0245112416667 1 0.0245112516667 0 0.024519995 0 0.024520005 1 0.0245312416667 1 0.0245312516667 0 0.024539995 0 0.024540005 1 0.0245512416667 1 0.0245512516667 0 0.024559995 0 0.024560005 1 0.0245712416667 1
+ 0.0245712516667 0 0.024579995 0 0.024580005 1 0.0245912416667 1 0.0245912516667 0 0.024599995 0 0.024600005 1 0.0246112416667 1 0.0246112516667 0 0.024619995 0 0.024620005 1 0.0246312416667 1 0.0246312516667 0 0.024639995 0 0.024640005 1 0.0246512416667 1
+ 0.0246512516667 0 0.024659995 0 0.024660005 1 0.0246712416667 1 0.0246712516667 0 0.024679995 0 0.024680005 1 0.0246912416667 1 0.0246912516667 0 0.024699995 0 0.024700005 1 0.0247112416667 1 0.0247112516667 0 0.024719995 0 0.024720005 1 0.0247312416667 1
+ 0.0247312516667 0 0.024739995 0 0.024740005 1 0.0247512416667 1 0.0247512516667 0 0.024759995 0 0.024760005 1 0.0247712416667 1 0.0247712516667 0 0.024779995 0 0.024780005 1 0.0247912416667 1 0.0247912516667 0 0.024799995 0 0.024800005 1 0.0248112416667 1
+ 0.0248112516667 0 0.024819995 0 0.024820005 1 0.0248312416667 1 0.0248312516667 0 0.024839995 0 0.024840005 1 0.0248512416667 1 0.0248512516667 0 0.024859995 0 0.024860005 1 0.0248712416667 1 0.0248712516667 0 0.024879995 0 0.024880005 1 0.0248912416667 1
+ 0.0248912516667 0 0.024899995 0 0.024900005 1 0.0249112416667 1 0.0249112516667 0 0.024919995 0 0.024920005 1 0.0249312416667 1 0.0249312516667 0 0.024939995 0 0.024940005 1 0.0249512416667 1 0.0249512516667 0 0.024959995 0 0.024960005 1 0.0249712416667 1
+ 0.0249712516667 0 0.024979995 0 0.024980005 1 0.0249912416667 1 0.0249912516667 0 0.024999995 0 0.025000005 1 0.0250112416667 1 0.0250112516667 0)
Vgls gls 0 PWL(0 0 2.95e-07 0 3.05e-07 1 1.9695e-05 1 1.9705e-05 0 2.04074666667e-05 0 2.04174666667e-05 1 3.9695e-05 1 3.9705e-05 0 4.05199333333e-05 0 4.05299333333e-05 1 5.9695e-05 1 5.9705e-05 0 6.06324e-05 0 6.06424e-05 1 7.9695e-05 1
+ 7.9705e-05 0 8.07448666667e-05 0 8.07548666667e-05 1 9.9695e-05 1 9.9705e-05 0 0.000100857333333 0 0.000100867333333 1 0.000119695 1 0.000119705 0 0.0001209698 0 0.0001209798 1 0.000139695 1 0.000139705 0 0.000141082266667 0 0.000141092266667 1 0.000159695 1
+ 0.000159705 0 0.000161194733333 0 0.000161204733333 1 0.000179695 1 0.000179705 0 0.0001813072 0 0.0001813172 1 0.000199695 1 0.000199705 0 0.000201419666667 0 0.000201429666667 1 0.000219695 1 0.000219705 0 0.000221532133333 0 0.000221542133333 1 0.000239695 1
+ 0.000239705 0 0.0002416446 0 0.0002416546 1 0.000259695 1 0.000259705 0 0.000261757066667 0 0.000261767066667 1 0.000279695 1 0.000279705 0 0.000281869533333 0 0.000281879533333 1 0.000299695 1 0.000299705 0 0.000301982 0 0.000301992 1 0.000319695 1
+ 0.000319705 0 0.000322094466667 0 0.000322104466667 1 0.000339695 1 0.000339705 0 0.000342206933333 0 0.000342216933333 1 0.000359695 1 0.000359705 0 0.0003623194 0 0.0003623294 1 0.000379695 1 0.000379705 0 0.000382431866667 0 0.000382441866667 1 0.000399695 1
+ 0.000399705 0 0.000402544333333 0 0.000402554333333 1 0.000419695 1 0.000419705 0 0.0004226568 0 0.0004226668 1 0.000439695 1 0.000439705 0 0.000442769266667 0 0.000442779266667 1 0.000459695 1 0.000459705 0 0.000462881733333 0 0.000462891733333 1 0.000479695 1
+ 0.000479705 0 0.0004829942 0 0.0004830042 1 0.000499695 1 0.000499705 0 0.000503106666667 0 0.000503116666667 1 0.000519695 1 0.000519705 0 0.000523219133333 0 0.000523229133333 1 0.000539695 1 0.000539705 0 0.0005433316 0 0.0005433416 1 0.000559695 1
+ 0.000559705 0 0.000563444066667 0 0.000563454066667 1 0.000579695 1 0.000579705 0 0.000583556533333 0 0.000583566533333 1 0.000599695 1 0.000599705 0 0.000603669 0 0.000603679 1 0.000619695 1 0.000619705 0 0.000623781466667 0 0.000623791466667 1 0.000639695 1
+ 0.000639705 0 0.000643893933333 0 0.000643903933333 1 0.000659695 1 0.000659705 0 0.0006640064 0 0.0006640164 1 0.000679695 1 0.000679705 0 0.000684118866667 0 0.000684128866667 1 0.000699695 1 0.000699705 0 0.000704231333333 0 0.000704241333333 1 0.000719695 1
+ 0.000719705 0 0.0007243438 0 0.0007243538 1 0.000739695 1 0.000739705 0 0.000744456266667 0 0.000744466266667 1 0.000759695 1 0.000759705 0 0.000764568733333 0 0.000764578733333 1 0.000779695 1 0.000779705 0 0.0007846812 0 0.0007846912 1 0.000799695 1
+ 0.000799705 0 0.000804793666667 0 0.000804803666667 1 0.000819695 1 0.000819705 0 0.000824906133333 0 0.000824916133333 1 0.000839695 1 0.000839705 0 0.0008450186 0 0.0008450286 1 0.000859695 1 0.000859705 0 0.000865131066667 0 0.000865141066667 1 0.000879695 1
+ 0.000879705 0 0.000885243533333 0 0.000885253533333 1 0.000899695 1 0.000899705 0 0.000905356 0 0.000905366 1 0.000919695 1 0.000919705 0 0.000925468466667 0 0.000925478466667 1 0.000939695 1 0.000939705 0 0.000945580933333 0 0.000945590933333 1 0.000959695 1
+ 0.000959705 0 0.0009656934 0 0.0009657034 1 0.000979695 1 0.000979705 0 0.000985805866667 0 0.000985815866667 1 0.000999695 1 0.000999705 0 0.00100591833333 0 0.00100592833333 1 0.001019695 1 0.001019705 0 0.0010260308 0 0.0010260408 1 0.001039695 1
+ 0.001039705 0 0.00104614326667 0 0.00104615326667 1 0.001059695 1 0.001059705 0 0.00106625573333 0 0.00106626573333 1 0.001079695 1 0.001079705 0 0.0010863682 0 0.0010863782 1 0.001099695 1 0.001099705 0 0.00110648066667 0 0.00110649066667 1 0.001119695 1
+ 0.001119705 0 0.00112659313333 0 0.00112660313333 1 0.001139695 1 0.001139705 0 0.0011467056 0 0.0011467156 1 0.001159695 1 0.001159705 0 0.00116681806667 0 0.00116682806667 1 0.001179695 1 0.001179705 0 0.00118693053333 0 0.00118694053333 1 0.001199695 1
+ 0.001199705 0 0.001207043 0 0.001207053 1 0.001219695 1 0.001219705 0 0.00122715546667 0 0.00122716546667 1 0.001239695 1 0.001239705 0 0.00124726793333 0 0.00124727793333 1 0.001259695 1 0.001259705 0 0.0012673804 0 0.0012673904 1 0.001279695 1
+ 0.001279705 0 0.00128749286667 0 0.00128750286667 1 0.001299695 1 0.001299705 0 0.00130760533333 0 0.00130761533333 1 0.001319695 1 0.001319705 0 0.0013277178 0 0.0013277278 1 0.001339695 1 0.001339705 0 0.00134783026667 0 0.00134784026667 1 0.001359695 1
+ 0.001359705 0 0.00136794273333 0 0.00136795273333 1 0.001379695 1 0.001379705 0 0.0013880552 0 0.0013880652 1 0.001399695 1 0.001399705 0 0.00140816766667 0 0.00140817766667 1 0.001419695 1 0.001419705 0 0.00142828013333 0 0.00142829013333 1 0.001439695 1
+ 0.001439705 0 0.0014483926 0 0.0014484026 1 0.001459695 1 0.001459705 0 0.00146850506667 0 0.00146851506667 1 0.001479695 1 0.001479705 0 0.00148861753333 0 0.00148862753333 1 0.001499695 1 0.001499705 0 0.00150873 0 0.00150874 1 0.001519695 1
+ 0.001519705 0 0.00152884246667 0 0.00152885246667 1 0.001539695 1 0.001539705 0 0.00154895493333 0 0.00154896493333 1 0.001559695 1 0.001559705 0 0.0015690674 0 0.0015690774 1 0.001579695 1 0.001579705 0 0.00158917986667 0 0.00158918986667 1 0.001599695 1
+ 0.001599705 0 0.00160929233333 0 0.00160930233333 1 0.001619695 1 0.001619705 0 0.0016294048 0 0.0016294148 1 0.001639695 1 0.001639705 0 0.00164951726667 0 0.00164952726667 1 0.001659695 1 0.001659705 0 0.00166962973333 0 0.00166963973333 1 0.001679695 1
+ 0.001679705 0 0.0016897422 0 0.0016897522 1 0.001699695 1 0.001699705 0 0.00170985466667 0 0.00170986466667 1 0.001719695 1 0.001719705 0 0.00172996713333 0 0.00172997713333 1 0.001739695 1 0.001739705 0 0.0017500796 0 0.0017500896 1 0.001759695 1
+ 0.001759705 0 0.00177019206667 0 0.00177020206667 1 0.001779695 1 0.001779705 0 0.00179030453333 0 0.00179031453333 1 0.001799695 1 0.001799705 0 0.001810417 0 0.001810427 1 0.001819695 1 0.001819705 0 0.00183052946667 0 0.00183053946667 1 0.001839695 1
+ 0.001839705 0 0.00185064193333 0 0.00185065193333 1 0.001859695 1 0.001859705 0 0.0018707544 0 0.0018707644 1 0.001879695 1 0.001879705 0 0.00189086686667 0 0.00189087686667 1 0.001899695 1 0.001899705 0 0.00191097933333 0 0.00191098933333 1 0.001919695 1
+ 0.001919705 0 0.0019310918 0 0.0019311018 1 0.001939695 1 0.001939705 0 0.00195120426667 0 0.00195121426667 1 0.001959695 1 0.001959705 0 0.00197131673333 0 0.00197132673333 1 0.001979695 1 0.001979705 0 0.0019914292 0 0.0019914392 1 0.001999695 1
+ 0.001999705 0 0.00201154166667 0 0.00201155166667 1 0.002019695 1 0.002019705 0 0.00203154166667 0 0.00203155166667 1 0.002039695 1 0.002039705 0 0.00205154166667 0 0.00205155166667 1 0.002059695 1 0.002059705 0 0.00207154166667 0 0.00207155166667 1 0.002079695 1
+ 0.002079705 0 0.00209154166667 0 0.00209155166667 1 0.002099695 1 0.002099705 0 0.00211154166667 0 0.00211155166667 1 0.002119695 1 0.002119705 0 0.00213154166667 0 0.00213155166667 1 0.002139695 1 0.002139705 0 0.00215154166667 0 0.00215155166667 1 0.002159695 1
+ 0.002159705 0 0.00217154166667 0 0.00217155166667 1 0.002179695 1 0.002179705 0 0.00219154166667 0 0.00219155166667 1 0.002199695 1 0.002199705 0 0.00221154166667 0 0.00221155166667 1 0.002219695 1 0.002219705 0 0.00223154166667 0 0.00223155166667 1 0.002239695 1
+ 0.002239705 0 0.00225154166667 0 0.00225155166667 1 0.002259695 1 0.002259705 0 0.00227154166667 0 0.00227155166667 1 0.002279695 1 0.002279705 0 0.00229154166667 0 0.00229155166667 1 0.002299695 1 0.002299705 0 0.00231154166667 0 0.00231155166667 1 0.002319695 1
+ 0.002319705 0 0.00233154166667 0 0.00233155166667 1 0.002339695 1 0.002339705 0 0.00235154166667 0 0.00235155166667 1 0.002359695 1 0.002359705 0 0.00237154166667 0 0.00237155166667 1 0.002379695 1 0.002379705 0 0.00239154166667 0 0.00239155166667 1 0.002399695 1
+ 0.002399705 0 0.00241154166667 0 0.00241155166667 1 0.002419695 1 0.002419705 0 0.00243154166667 0 0.00243155166667 1 0.002439695 1 0.002439705 0 0.00245154166667 0 0.00245155166667 1 0.002459695 1 0.002459705 0 0.00247154166667 0 0.00247155166667 1 0.002479695 1
+ 0.002479705 0 0.00249154166667 0 0.00249155166667 1 0.002499695 1 0.002499705 0 0.00251154166667 0 0.00251155166667 1 0.002519695 1 0.002519705 0 0.00253154166667 0 0.00253155166667 1 0.002539695 1 0.002539705 0 0.00255154166667 0 0.00255155166667 1 0.002559695 1
+ 0.002559705 0 0.00257154166667 0 0.00257155166667 1 0.002579695 1 0.002579705 0 0.00259154166667 0 0.00259155166667 1 0.002599695 1 0.002599705 0 0.00261154166667 0 0.00261155166667 1 0.002619695 1 0.002619705 0 0.00263154166667 0 0.00263155166667 1 0.002639695 1
+ 0.002639705 0 0.00265154166667 0 0.00265155166667 1 0.002659695 1 0.002659705 0 0.00267154166667 0 0.00267155166667 1 0.002679695 1 0.002679705 0 0.00269154166667 0 0.00269155166667 1 0.002699695 1 0.002699705 0 0.00271154166667 0 0.00271155166667 1 0.002719695 1
+ 0.002719705 0 0.00273154166667 0 0.00273155166667 1 0.002739695 1 0.002739705 0 0.00275154166667 0 0.00275155166667 1 0.002759695 1 0.002759705 0 0.00277154166667 0 0.00277155166667 1 0.002779695 1 0.002779705 0 0.00279154166667 0 0.00279155166667 1 0.002799695 1
+ 0.002799705 0 0.00281154166667 0 0.00281155166667 1 0.002819695 1 0.002819705 0 0.00283154166667 0 0.00283155166667 1 0.002839695 1 0.002839705 0 0.00285154166667 0 0.00285155166667 1 0.002859695 1 0.002859705 0 0.00287154166667 0 0.00287155166667 1 0.002879695 1
+ 0.002879705 0 0.00289154166667 0 0.00289155166667 1 0.002899695 1 0.002899705 0 0.00291154166667 0 0.00291155166667 1 0.002919695 1 0.002919705 0 0.00293154166667 0 0.00293155166667 1 0.002939695 1 0.002939705 0 0.00295154166667 0 0.00295155166667 1 0.002959695 1
+ 0.002959705 0 0.00297154166667 0 0.00297155166667 1 0.002979695 1 0.002979705 0 0.00299154166667 0 0.00299155166667 1 0.002999695 1 0.002999705 0 0.00301154166667 0 0.00301155166667 1 0.003019695 1 0.003019705 0 0.00303154166667 0 0.00303155166667 1 0.003039695 1
+ 0.003039705 0 0.00305154166667 0 0.00305155166667 1 0.003059695 1 0.003059705 0 0.00307154166667 0 0.00307155166667 1 0.003079695 1 0.003079705 0 0.00309154166667 0 0.00309155166667 1 0.003099695 1 0.003099705 0 0.00311154166667 0 0.00311155166667 1 0.003119695 1
+ 0.003119705 0 0.00313154166667 0 0.00313155166667 1 0.003139695 1 0.003139705 0 0.00315154166667 0 0.00315155166667 1 0.003159695 1 0.003159705 0 0.00317154166667 0 0.00317155166667 1 0.003179695 1 0.003179705 0 0.00319154166667 0 0.00319155166667 1 0.003199695 1
+ 0.003199705 0 0.00321154166667 0 0.00321155166667 1 0.003219695 1 0.003219705 0 0.00323154166667 0 0.00323155166667 1 0.003239695 1 0.003239705 0 0.00325154166667 0 0.00325155166667 1 0.003259695 1 0.003259705 0 0.00327154166667 0 0.00327155166667 1 0.003279695 1
+ 0.003279705 0 0.00329154166667 0 0.00329155166667 1 0.003299695 1 0.003299705 0 0.00331154166667 0 0.00331155166667 1 0.003319695 1 0.003319705 0 0.00333154166667 0 0.00333155166667 1 0.003339695 1 0.003339705 0 0.00335154166667 0 0.00335155166667 1 0.003359695 1
+ 0.003359705 0 0.00337154166667 0 0.00337155166667 1 0.003379695 1 0.003379705 0 0.00339154166667 0 0.00339155166667 1 0.003399695 1 0.003399705 0 0.00341154166667 0 0.00341155166667 1 0.003419695 1 0.003419705 0 0.00343154166667 0 0.00343155166667 1 0.003439695 1
+ 0.003439705 0 0.00345154166667 0 0.00345155166667 1 0.003459695 1 0.003459705 0 0.00347154166667 0 0.00347155166667 1 0.003479695 1 0.003479705 0 0.00349154166667 0 0.00349155166667 1 0.003499695 1 0.003499705 0 0.00351154166667 0 0.00351155166667 1 0.003519695 1
+ 0.003519705 0 0.00353154166667 0 0.00353155166667 1 0.003539695 1 0.003539705 0 0.00355154166667 0 0.00355155166667 1 0.003559695 1 0.003559705 0 0.00357154166667 0 0.00357155166667 1 0.003579695 1 0.003579705 0 0.00359154166667 0 0.00359155166667 1 0.003599695 1
+ 0.003599705 0 0.00361154166667 0 0.00361155166667 1 0.003619695 1 0.003619705 0 0.00363154166667 0 0.00363155166667 1 0.003639695 1 0.003639705 0 0.00365154166667 0 0.00365155166667 1 0.003659695 1 0.003659705 0 0.00367154166667 0 0.00367155166667 1 0.003679695 1
+ 0.003679705 0 0.00369154166667 0 0.00369155166667 1 0.003699695 1 0.003699705 0 0.00371154166667 0 0.00371155166667 1 0.003719695 1 0.003719705 0 0.00373154166667 0 0.00373155166667 1 0.003739695 1 0.003739705 0 0.00375154166667 0 0.00375155166667 1 0.003759695 1
+ 0.003759705 0 0.00377154166667 0 0.00377155166667 1 0.003779695 1 0.003779705 0 0.00379154166667 0 0.00379155166667 1 0.003799695 1 0.003799705 0 0.00381154166667 0 0.00381155166667 1 0.003819695 1 0.003819705 0 0.00383154166667 0 0.00383155166667 1 0.003839695 1
+ 0.003839705 0 0.00385154166667 0 0.00385155166667 1 0.003859695 1 0.003859705 0 0.00387154166667 0 0.00387155166667 1 0.003879695 1 0.003879705 0 0.00389154166667 0 0.00389155166667 1 0.003899695 1 0.003899705 0 0.00391154166667 0 0.00391155166667 1 0.003919695 1
+ 0.003919705 0 0.00393154166667 0 0.00393155166667 1 0.003939695 1 0.003939705 0 0.00395154166667 0 0.00395155166667 1 0.003959695 1 0.003959705 0 0.00397154166667 0 0.00397155166667 1 0.003979695 1 0.003979705 0 0.00399154166667 0 0.00399155166667 1 0.003999695 1
+ 0.003999705 0 0.00401154166667 0 0.00401155166667 1 0.004019695 1 0.004019705 0 0.00403154166667 0 0.00403155166667 1 0.004039695 1 0.004039705 0 0.00405154166667 0 0.00405155166667 1 0.004059695 1 0.004059705 0 0.00407154166667 0 0.00407155166667 1 0.004079695 1
+ 0.004079705 0 0.00409154166667 0 0.00409155166667 1 0.004099695 1 0.004099705 0 0.00411154166667 0 0.00411155166667 1 0.004119695 1 0.004119705 0 0.00413154166667 0 0.00413155166667 1 0.004139695 1 0.004139705 0 0.00415154166667 0 0.00415155166667 1 0.004159695 1
+ 0.004159705 0 0.00417154166667 0 0.00417155166667 1 0.004179695 1 0.004179705 0 0.00419154166667 0 0.00419155166667 1 0.004199695 1 0.004199705 0 0.00421154166667 0 0.00421155166667 1 0.004219695 1 0.004219705 0 0.00423154166667 0 0.00423155166667 1 0.004239695 1
+ 0.004239705 0 0.00425154166667 0 0.00425155166667 1 0.004259695 1 0.004259705 0 0.00427154166667 0 0.00427155166667 1 0.004279695 1 0.004279705 0 0.00429154166667 0 0.00429155166667 1 0.004299695 1 0.004299705 0 0.00431154166667 0 0.00431155166667 1 0.004319695 1
+ 0.004319705 0 0.00433154166667 0 0.00433155166667 1 0.004339695 1 0.004339705 0 0.00435154166667 0 0.00435155166667 1 0.004359695 1 0.004359705 0 0.00437154166667 0 0.00437155166667 1 0.004379695 1 0.004379705 0 0.00439154166667 0 0.00439155166667 1 0.004399695 1
+ 0.004399705 0 0.00441154166667 0 0.00441155166667 1 0.004419695 1 0.004419705 0 0.00443154166667 0 0.00443155166667 1 0.004439695 1 0.004439705 0 0.00445154166667 0 0.00445155166667 1 0.004459695 1 0.004459705 0 0.00447154166667 0 0.00447155166667 1 0.004479695 1
+ 0.004479705 0 0.00449154166667 0 0.00449155166667 1 0.004499695 1 0.004499705 0 0.00451154166667 0 0.00451155166667 1 0.004519695 1 0.004519705 0 0.00453154166667 0 0.00453155166667 1 0.004539695 1 0.004539705 0 0.00455154166667 0 0.00455155166667 1 0.004559695 1
+ 0.004559705 0 0.00457154166667 0 0.00457155166667 1 0.004579695 1 0.004579705 0 0.00459154166667 0 0.00459155166667 1 0.004599695 1 0.004599705 0 0.00461154166667 0 0.00461155166667 1 0.004619695 1 0.004619705 0 0.00463154166667 0 0.00463155166667 1 0.004639695 1
+ 0.004639705 0 0.00465154166667 0 0.00465155166667 1 0.004659695 1 0.004659705 0 0.00467154166667 0 0.00467155166667 1 0.004679695 1 0.004679705 0 0.00469154166667 0 0.00469155166667 1 0.004699695 1 0.004699705 0 0.00471154166667 0 0.00471155166667 1 0.004719695 1
+ 0.004719705 0 0.00473154166667 0 0.00473155166667 1 0.004739695 1 0.004739705 0 0.00475154166667 0 0.00475155166667 1 0.004759695 1 0.004759705 0 0.00477154166667 0 0.00477155166667 1 0.004779695 1 0.004779705 0 0.00479154166667 0 0.00479155166667 1 0.004799695 1
+ 0.004799705 0 0.00481154166667 0 0.00481155166667 1 0.004819695 1 0.004819705 0 0.00483154166667 0 0.00483155166667 1 0.004839695 1 0.004839705 0 0.00485154166667 0 0.00485155166667 1 0.004859695 1 0.004859705 0 0.00487154166667 0 0.00487155166667 1 0.004879695 1
+ 0.004879705 0 0.00489154166667 0 0.00489155166667 1 0.004899695 1 0.004899705 0 0.00491154166667 0 0.00491155166667 1 0.004919695 1 0.004919705 0 0.00493154166667 0 0.00493155166667 1 0.004939695 1 0.004939705 0 0.00495154166667 0 0.00495155166667 1 0.004959695 1
+ 0.004959705 0 0.00497154166667 0 0.00497155166667 1 0.004979695 1 0.004979705 0 0.00499154166667 0 0.00499155166667 1 0.004999695 1 0.004999705 0 0.00501154166667 0 0.00501155166667 1 0.005019695 1 0.005019705 0 0.00503154166667 0 0.00503155166667 1 0.005039695 1
+ 0.005039705 0 0.00505154166667 0 0.00505155166667 1 0.005059695 1 0.005059705 0 0.00507154166667 0 0.00507155166667 1 0.005079695 1 0.005079705 0 0.00509154166667 0 0.00509155166667 1 0.005099695 1 0.005099705 0 0.00511154166667 0 0.00511155166667 1 0.005119695 1
+ 0.005119705 0 0.00513154166667 0 0.00513155166667 1 0.005139695 1 0.005139705 0 0.00515154166667 0 0.00515155166667 1 0.005159695 1 0.005159705 0 0.00517154166667 0 0.00517155166667 1 0.005179695 1 0.005179705 0 0.00519154166667 0 0.00519155166667 1 0.005199695 1
+ 0.005199705 0 0.00521154166667 0 0.00521155166667 1 0.005219695 1 0.005219705 0 0.00523154166667 0 0.00523155166667 1 0.005239695 1 0.005239705 0 0.00525154166667 0 0.00525155166667 1 0.005259695 1 0.005259705 0 0.00527154166667 0 0.00527155166667 1 0.005279695 1
+ 0.005279705 0 0.00529154166667 0 0.00529155166667 1 0.005299695 1 0.005299705 0 0.00531154166667 0 0.00531155166667 1 0.005319695 1 0.005319705 0 0.00533154166667 0 0.00533155166667 1 0.005339695 1 0.005339705 0 0.00535154166667 0 0.00535155166667 1 0.005359695 1
+ 0.005359705 0 0.00537154166667 0 0.00537155166667 1 0.005379695 1 0.005379705 0 0.00539154166667 0 0.00539155166667 1 0.005399695 1 0.005399705 0 0.00541154166667 0 0.00541155166667 1 0.005419695 1 0.005419705 0 0.00543154166667 0 0.00543155166667 1 0.005439695 1
+ 0.005439705 0 0.00545154166667 0 0.00545155166667 1 0.005459695 1 0.005459705 0 0.00547154166667 0 0.00547155166667 1 0.005479695 1 0.005479705 0 0.00549154166667 0 0.00549155166667 1 0.005499695 1 0.005499705 0 0.00551154166667 0 0.00551155166667 1 0.005519695 1
+ 0.005519705 0 0.00553154166667 0 0.00553155166667 1 0.005539695 1 0.005539705 0 0.00555154166667 0 0.00555155166667 1 0.005559695 1 0.005559705 0 0.00557154166667 0 0.00557155166667 1 0.005579695 1 0.005579705 0 0.00559154166667 0 0.00559155166667 1 0.005599695 1
+ 0.005599705 0 0.00561154166667 0 0.00561155166667 1 0.005619695 1 0.005619705 0 0.00563154166667 0 0.00563155166667 1 0.005639695 1 0.005639705 0 0.00565154166667 0 0.00565155166667 1 0.005659695 1 0.005659705 0 0.00567154166667 0 0.00567155166667 1 0.005679695 1
+ 0.005679705 0 0.00569154166667 0 0.00569155166667 1 0.005699695 1 0.005699705 0 0.00571154166667 0 0.00571155166667 1 0.005719695 1 0.005719705 0 0.00573154166667 0 0.00573155166667 1 0.005739695 1 0.005739705 0 0.00575154166667 0 0.00575155166667 1 0.005759695 1
+ 0.005759705 0 0.00577154166667 0 0.00577155166667 1 0.005779695 1 0.005779705 0 0.00579154166667 0 0.00579155166667 1 0.005799695 1 0.005799705 0 0.00581154166667 0 0.00581155166667 1 0.005819695 1 0.005819705 0 0.00583154166667 0 0.00583155166667 1 0.005839695 1
+ 0.005839705 0 0.00585154166667 0 0.00585155166667 1 0.005859695 1 0.005859705 0 0.00587154166667 0 0.00587155166667 1 0.005879695 1 0.005879705 0 0.00589154166667 0 0.00589155166667 1 0.005899695 1 0.005899705 0 0.00591154166667 0 0.00591155166667 1 0.005919695 1
+ 0.005919705 0 0.00593154166667 0 0.00593155166667 1 0.005939695 1 0.005939705 0 0.00595154166667 0 0.00595155166667 1 0.005959695 1 0.005959705 0 0.00597154166667 0 0.00597155166667 1 0.005979695 1 0.005979705 0 0.00599154166667 0 0.00599155166667 1 0.005999695 1
+ 0.005999705 0 0.00601154166667 0 0.00601155166667 1 0.006019695 1 0.006019705 0 0.00603154166667 0 0.00603155166667 1 0.006039695 1 0.006039705 0 0.00605154166667 0 0.00605155166667 1 0.006059695 1 0.006059705 0 0.00607154166667 0 0.00607155166667 1 0.006079695 1
+ 0.006079705 0 0.00609154166667 0 0.00609155166667 1 0.006099695 1 0.006099705 0 0.00611154166667 0 0.00611155166667 1 0.006119695 1 0.006119705 0 0.00613154166667 0 0.00613155166667 1 0.006139695 1 0.006139705 0 0.00615154166667 0 0.00615155166667 1 0.006159695 1
+ 0.006159705 0 0.00617154166667 0 0.00617155166667 1 0.006179695 1 0.006179705 0 0.00619154166667 0 0.00619155166667 1 0.006199695 1 0.006199705 0 0.00621154166667 0 0.00621155166667 1 0.006219695 1 0.006219705 0 0.00623154166667 0 0.00623155166667 1 0.006239695 1
+ 0.006239705 0 0.00625154166667 0 0.00625155166667 1 0.006259695 1 0.006259705 0 0.00627154166667 0 0.00627155166667 1 0.006279695 1 0.006279705 0 0.00629154166667 0 0.00629155166667 1 0.006299695 1 0.006299705 0 0.00631154166667 0 0.00631155166667 1 0.006319695 1
+ 0.006319705 0 0.00633154166667 0 0.00633155166667 1 0.006339695 1 0.006339705 0 0.00635154166667 0 0.00635155166667 1 0.006359695 1 0.006359705 0 0.00637154166667 0 0.00637155166667 1 0.006379695 1 0.006379705 0 0.00639154166667 0 0.00639155166667 1 0.006399695 1
+ 0.006399705 0 0.00641154166667 0 0.00641155166667 1 0.006419695 1 0.006419705 0 0.00643154166667 0 0.00643155166667 1 0.006439695 1 0.006439705 0 0.00645154166667 0 0.00645155166667 1 0.006459695 1 0.006459705 0 0.00647154166667 0 0.00647155166667 1 0.006479695 1
+ 0.006479705 0 0.00649154166667 0 0.00649155166667 1 0.006499695 1 0.006499705 0 0.00651154166667 0 0.00651155166667 1 0.006519695 1 0.006519705 0 0.00653154166667 0 0.00653155166667 1 0.006539695 1 0.006539705 0 0.00655154166667 0 0.00655155166667 1 0.006559695 1
+ 0.006559705 0 0.00657154166667 0 0.00657155166667 1 0.006579695 1 0.006579705 0 0.00659154166667 0 0.00659155166667 1 0.006599695 1 0.006599705 0 0.00661154166667 0 0.00661155166667 1 0.006619695 1 0.006619705 0 0.00663154166667 0 0.00663155166667 1 0.006639695 1
+ 0.006639705 0 0.00665154166667 0 0.00665155166667 1 0.006659695 1 0.006659705 0 0.00667154166667 0 0.00667155166667 1 0.006679695 1 0.006679705 0 0.00669154166667 0 0.00669155166667 1 0.006699695 1 0.006699705 0 0.00671154166667 0 0.00671155166667 1 0.006719695 1
+ 0.006719705 0 0.00673154166667 0 0.00673155166667 1 0.006739695 1 0.006739705 0 0.00675154166667 0 0.00675155166667 1 0.006759695 1 0.006759705 0 0.00677154166667 0 0.00677155166667 1 0.006779695 1 0.006779705 0 0.00679154166667 0 0.00679155166667 1 0.006799695 1
+ 0.006799705 0 0.00681154166667 0 0.00681155166667 1 0.006819695 1 0.006819705 0 0.00683154166667 0 0.00683155166667 1 0.006839695 1 0.006839705 0 0.00685154166667 0 0.00685155166667 1 0.006859695 1 0.006859705 0 0.00687154166667 0 0.00687155166667 1 0.006879695 1
+ 0.006879705 0 0.00689154166667 0 0.00689155166667 1 0.006899695 1 0.006899705 0 0.00691154166667 0 0.00691155166667 1 0.006919695 1 0.006919705 0 0.00693154166667 0 0.00693155166667 1 0.006939695 1 0.006939705 0 0.00695154166667 0 0.00695155166667 1 0.006959695 1
+ 0.006959705 0 0.00697154166667 0 0.00697155166667 1 0.006979695 1 0.006979705 0 0.00699154166667 0 0.00699155166667 1 0.006999695 1 0.006999705 0 0.00701154166667 0 0.00701155166667 1 0.007019695 1 0.007019705 0 0.00703154166667 0 0.00703155166667 1 0.007039695 1
+ 0.007039705 0 0.00705154166667 0 0.00705155166667 1 0.007059695 1 0.007059705 0 0.00707154166667 0 0.00707155166667 1 0.007079695 1 0.007079705 0 0.00709154166667 0 0.00709155166667 1 0.007099695 1 0.007099705 0 0.00711154166667 0 0.00711155166667 1 0.007119695 1
+ 0.007119705 0 0.00713154166667 0 0.00713155166667 1 0.007139695 1 0.007139705 0 0.00715154166667 0 0.00715155166667 1 0.007159695 1 0.007159705 0 0.00717154166667 0 0.00717155166667 1 0.007179695 1 0.007179705 0 0.00719154166667 0 0.00719155166667 1 0.007199695 1
+ 0.007199705 0 0.00721154166667 0 0.00721155166667 1 0.007219695 1 0.007219705 0 0.00723154166667 0 0.00723155166667 1 0.007239695 1 0.007239705 0 0.00725154166667 0 0.00725155166667 1 0.007259695 1 0.007259705 0 0.00727154166667 0 0.00727155166667 1 0.007279695 1
+ 0.007279705 0 0.00729154166667 0 0.00729155166667 1 0.007299695 1 0.007299705 0 0.00731154166667 0 0.00731155166667 1 0.007319695 1 0.007319705 0 0.00733154166667 0 0.00733155166667 1 0.007339695 1 0.007339705 0 0.00735154166667 0 0.00735155166667 1 0.007359695 1
+ 0.007359705 0 0.00737154166667 0 0.00737155166667 1 0.007379695 1 0.007379705 0 0.00739154166667 0 0.00739155166667 1 0.007399695 1 0.007399705 0 0.00741154166667 0 0.00741155166667 1 0.007419695 1 0.007419705 0 0.00743154166667 0 0.00743155166667 1 0.007439695 1
+ 0.007439705 0 0.00745154166667 0 0.00745155166667 1 0.007459695 1 0.007459705 0 0.00747154166667 0 0.00747155166667 1 0.007479695 1 0.007479705 0 0.00749154166667 0 0.00749155166667 1 0.007499695 1 0.007499705 0 0.00751154166667 0 0.00751155166667 1 0.007519695 1
+ 0.007519705 0 0.00753154166667 0 0.00753155166667 1 0.007539695 1 0.007539705 0 0.00755154166667 0 0.00755155166667 1 0.007559695 1 0.007559705 0 0.00757154166667 0 0.00757155166667 1 0.007579695 1 0.007579705 0 0.00759154166667 0 0.00759155166667 1 0.007599695 1
+ 0.007599705 0 0.00761154166667 0 0.00761155166667 1 0.007619695 1 0.007619705 0 0.00763154166667 0 0.00763155166667 1 0.007639695 1 0.007639705 0 0.00765154166667 0 0.00765155166667 1 0.007659695 1 0.007659705 0 0.00767154166667 0 0.00767155166667 1 0.007679695 1
+ 0.007679705 0 0.00769154166667 0 0.00769155166667 1 0.007699695 1 0.007699705 0 0.00771154166667 0 0.00771155166667 1 0.007719695 1 0.007719705 0 0.00773154166667 0 0.00773155166667 1 0.007739695 1 0.007739705 0 0.00775154166667 0 0.00775155166667 1 0.007759695 1
+ 0.007759705 0 0.00777154166667 0 0.00777155166667 1 0.007779695 1 0.007779705 0 0.00779154166667 0 0.00779155166667 1 0.007799695 1 0.007799705 0 0.00781154166667 0 0.00781155166667 1 0.007819695 1 0.007819705 0 0.00783154166667 0 0.00783155166667 1 0.007839695 1
+ 0.007839705 0 0.00785154166667 0 0.00785155166667 1 0.007859695 1 0.007859705 0 0.00787154166667 0 0.00787155166667 1 0.007879695 1 0.007879705 0 0.00789154166667 0 0.00789155166667 1 0.007899695 1 0.007899705 0 0.00791154166667 0 0.00791155166667 1 0.007919695 1
+ 0.007919705 0 0.00793154166667 0 0.00793155166667 1 0.007939695 1 0.007939705 0 0.00795154166667 0 0.00795155166667 1 0.007959695 1 0.007959705 0 0.00797154166667 0 0.00797155166667 1 0.007979695 1 0.007979705 0 0.00799154166667 0 0.00799155166667 1 0.007999695 1
+ 0.007999705 0 0.00801154166667 0 0.00801155166667 1 0.008019695 1 0.008019705 0 0.00803154166667 0 0.00803155166667 1 0.008039695 1 0.008039705 0 0.00805154166667 0 0.00805155166667 1 0.008059695 1 0.008059705 0 0.00807154166667 0 0.00807155166667 1 0.008079695 1
+ 0.008079705 0 0.00809154166667 0 0.00809155166667 1 0.008099695 1 0.008099705 0 0.00811154166667 0 0.00811155166667 1 0.008119695 1 0.008119705 0 0.00813154166667 0 0.00813155166667 1 0.008139695 1 0.008139705 0 0.00815154166667 0 0.00815155166667 1 0.008159695 1
+ 0.008159705 0 0.00817154166667 0 0.00817155166667 1 0.008179695 1 0.008179705 0 0.00819154166667 0 0.00819155166667 1 0.008199695 1 0.008199705 0 0.00821154166667 0 0.00821155166667 1 0.008219695 1 0.008219705 0 0.00823154166667 0 0.00823155166667 1 0.008239695 1
+ 0.008239705 0 0.00825154166667 0 0.00825155166667 1 0.008259695 1 0.008259705 0 0.00827154166667 0 0.00827155166667 1 0.008279695 1 0.008279705 0 0.00829154166667 0 0.00829155166667 1 0.008299695 1 0.008299705 0 0.00831154166667 0 0.00831155166667 1 0.008319695 1
+ 0.008319705 0 0.00833154166667 0 0.00833155166667 1 0.008339695 1 0.008339705 0 0.00835154166667 0 0.00835155166667 1 0.008359695 1 0.008359705 0 0.00837154166667 0 0.00837155166667 1 0.008379695 1 0.008379705 0 0.00839154166667 0 0.00839155166667 1 0.008399695 1
+ 0.008399705 0 0.00841154166667 0 0.00841155166667 1 0.008419695 1 0.008419705 0 0.00843154166667 0 0.00843155166667 1 0.008439695 1 0.008439705 0 0.00845154166667 0 0.00845155166667 1 0.008459695 1 0.008459705 0 0.00847154166667 0 0.00847155166667 1 0.008479695 1
+ 0.008479705 0 0.00849154166667 0 0.00849155166667 1 0.008499695 1 0.008499705 0 0.00851154166667 0 0.00851155166667 1 0.008519695 1 0.008519705 0 0.00853154166667 0 0.00853155166667 1 0.008539695 1 0.008539705 0 0.00855154166667 0 0.00855155166667 1 0.008559695 1
+ 0.008559705 0 0.00857154166667 0 0.00857155166667 1 0.008579695 1 0.008579705 0 0.00859154166667 0 0.00859155166667 1 0.008599695 1 0.008599705 0 0.00861154166667 0 0.00861155166667 1 0.008619695 1 0.008619705 0 0.00863154166667 0 0.00863155166667 1 0.008639695 1
+ 0.008639705 0 0.00865154166667 0 0.00865155166667 1 0.008659695 1 0.008659705 0 0.00867154166667 0 0.00867155166667 1 0.008679695 1 0.008679705 0 0.00869154166667 0 0.00869155166667 1 0.008699695 1 0.008699705 0 0.00871154166667 0 0.00871155166667 1 0.008719695 1
+ 0.008719705 0 0.00873154166667 0 0.00873155166667 1 0.008739695 1 0.008739705 0 0.00875154166667 0 0.00875155166667 1 0.008759695 1 0.008759705 0 0.00877154166667 0 0.00877155166667 1 0.008779695 1 0.008779705 0 0.00879154166667 0 0.00879155166667 1 0.008799695 1
+ 0.008799705 0 0.00881154166667 0 0.00881155166667 1 0.008819695 1 0.008819705 0 0.00883154166667 0 0.00883155166667 1 0.008839695 1 0.008839705 0 0.00885154166667 0 0.00885155166667 1 0.008859695 1 0.008859705 0 0.00887154166667 0 0.00887155166667 1 0.008879695 1
+ 0.008879705 0 0.00889154166667 0 0.00889155166667 1 0.008899695 1 0.008899705 0 0.00891154166667 0 0.00891155166667 1 0.008919695 1 0.008919705 0 0.00893154166667 0 0.00893155166667 1 0.008939695 1 0.008939705 0 0.00895154166667 0 0.00895155166667 1 0.008959695 1
+ 0.008959705 0 0.00897154166667 0 0.00897155166667 1 0.008979695 1 0.008979705 0 0.00899154166667 0 0.00899155166667 1 0.008999695 1 0.008999705 0 0.00901154166667 0 0.00901155166667 1 0.009019695 1 0.009019705 0 0.00903154166667 0 0.00903155166667 1 0.009039695 1
+ 0.009039705 0 0.00905154166667 0 0.00905155166667 1 0.009059695 1 0.009059705 0 0.00907154166667 0 0.00907155166667 1 0.009079695 1 0.009079705 0 0.00909154166667 0 0.00909155166667 1 0.009099695 1 0.009099705 0 0.00911154166667 0 0.00911155166667 1 0.009119695 1
+ 0.009119705 0 0.00913154166667 0 0.00913155166667 1 0.009139695 1 0.009139705 0 0.00915154166667 0 0.00915155166667 1 0.009159695 1 0.009159705 0 0.00917154166667 0 0.00917155166667 1 0.009179695 1 0.009179705 0 0.00919154166667 0 0.00919155166667 1 0.009199695 1
+ 0.009199705 0 0.00921154166667 0 0.00921155166667 1 0.009219695 1 0.009219705 0 0.00923154166667 0 0.00923155166667 1 0.009239695 1 0.009239705 0 0.00925154166667 0 0.00925155166667 1 0.009259695 1 0.009259705 0 0.00927154166667 0 0.00927155166667 1 0.009279695 1
+ 0.009279705 0 0.00929154166667 0 0.00929155166667 1 0.009299695 1 0.009299705 0 0.00931154166667 0 0.00931155166667 1 0.009319695 1 0.009319705 0 0.00933154166667 0 0.00933155166667 1 0.009339695 1 0.009339705 0 0.00935154166667 0 0.00935155166667 1 0.009359695 1
+ 0.009359705 0 0.00937154166667 0 0.00937155166667 1 0.009379695 1 0.009379705 0 0.00939154166667 0 0.00939155166667 1 0.009399695 1 0.009399705 0 0.00941154166667 0 0.00941155166667 1 0.009419695 1 0.009419705 0 0.00943154166667 0 0.00943155166667 1 0.009439695 1
+ 0.009439705 0 0.00945154166667 0 0.00945155166667 1 0.009459695 1 0.009459705 0 0.00947154166667 0 0.00947155166667 1 0.009479695 1 0.009479705 0 0.00949154166667 0 0.00949155166667 1 0.009499695 1 0.009499705 0 0.00951154166667 0 0.00951155166667 1 0.009519695 1
+ 0.009519705 0 0.00953154166667 0 0.00953155166667 1 0.009539695 1 0.009539705 0 0.00955154166667 0 0.00955155166667 1 0.009559695 1 0.009559705 0 0.00957154166667 0 0.00957155166667 1 0.009579695 1 0.009579705 0 0.00959154166667 0 0.00959155166667 1 0.009599695 1
+ 0.009599705 0 0.00961154166667 0 0.00961155166667 1 0.009619695 1 0.009619705 0 0.00963154166667 0 0.00963155166667 1 0.009639695 1 0.009639705 0 0.00965154166667 0 0.00965155166667 1 0.009659695 1 0.009659705 0 0.00967154166667 0 0.00967155166667 1 0.009679695 1
+ 0.009679705 0 0.00969154166667 0 0.00969155166667 1 0.009699695 1 0.009699705 0 0.00971154166667 0 0.00971155166667 1 0.009719695 1 0.009719705 0 0.00973154166667 0 0.00973155166667 1 0.009739695 1 0.009739705 0 0.00975154166667 0 0.00975155166667 1 0.009759695 1
+ 0.009759705 0 0.00977154166667 0 0.00977155166667 1 0.009779695 1 0.009779705 0 0.00979154166667 0 0.00979155166667 1 0.009799695 1 0.009799705 0 0.00981154166667 0 0.00981155166667 1 0.009819695 1 0.009819705 0 0.00983154166667 0 0.00983155166667 1 0.009839695 1
+ 0.009839705 0 0.00985154166667 0 0.00985155166667 1 0.009859695 1 0.009859705 0 0.00987154166667 0 0.00987155166667 1 0.009879695 1 0.009879705 0 0.00989154166667 0 0.00989155166667 1 0.009899695 1 0.009899705 0 0.00991154166667 0 0.00991155166667 1 0.009919695 1
+ 0.009919705 0 0.00993154166667 0 0.00993155166667 1 0.009939695 1 0.009939705 0 0.00995154166667 0 0.00995155166667 1 0.009959695 1 0.009959705 0 0.00997154166667 0 0.00997155166667 1 0.009979695 1 0.009979705 0 0.00999154166667 0 0.00999155166667 1 0.009999695 1
+ 0.009999705 0 0.0100115416667 0 0.0100115516667 1 0.010019695 1 0.010019705 0 0.0100315416667 0 0.0100315516667 1 0.010039695 1 0.010039705 0 0.0100515416667 0 0.0100515516667 1 0.010059695 1 0.010059705 0 0.0100715416667 0 0.0100715516667 1 0.010079695 1
+ 0.010079705 0 0.0100915416667 0 0.0100915516667 1 0.010099695 1 0.010099705 0 0.0101115416667 0 0.0101115516667 1 0.010119695 1 0.010119705 0 0.0101315416667 0 0.0101315516667 1 0.010139695 1 0.010139705 0 0.0101515416667 0 0.0101515516667 1 0.010159695 1
+ 0.010159705 0 0.0101715416667 0 0.0101715516667 1 0.010179695 1 0.010179705 0 0.0101915416667 0 0.0101915516667 1 0.010199695 1 0.010199705 0 0.0102115416667 0 0.0102115516667 1 0.010219695 1 0.010219705 0 0.0102315416667 0 0.0102315516667 1 0.010239695 1
+ 0.010239705 0 0.0102515416667 0 0.0102515516667 1 0.010259695 1 0.010259705 0 0.0102715416667 0 0.0102715516667 1 0.010279695 1 0.010279705 0 0.0102915416667 0 0.0102915516667 1 0.010299695 1 0.010299705 0 0.0103115416667 0 0.0103115516667 1 0.010319695 1
+ 0.010319705 0 0.0103315416667 0 0.0103315516667 1 0.010339695 1 0.010339705 0 0.0103515416667 0 0.0103515516667 1 0.010359695 1 0.010359705 0 0.0103715416667 0 0.0103715516667 1 0.010379695 1 0.010379705 0 0.0103915416667 0 0.0103915516667 1 0.010399695 1
+ 0.010399705 0 0.0104115416667 0 0.0104115516667 1 0.010419695 1 0.010419705 0 0.0104315416667 0 0.0104315516667 1 0.010439695 1 0.010439705 0 0.0104515416667 0 0.0104515516667 1 0.010459695 1 0.010459705 0 0.0104715416667 0 0.0104715516667 1 0.010479695 1
+ 0.010479705 0 0.0104915416667 0 0.0104915516667 1 0.010499695 1 0.010499705 0 0.0105115416667 0 0.0105115516667 1 0.010519695 1 0.010519705 0 0.0105315416667 0 0.0105315516667 1 0.010539695 1 0.010539705 0 0.0105515416667 0 0.0105515516667 1 0.010559695 1
+ 0.010559705 0 0.0105715416667 0 0.0105715516667 1 0.010579695 1 0.010579705 0 0.0105915416667 0 0.0105915516667 1 0.010599695 1 0.010599705 0 0.0106115416667 0 0.0106115516667 1 0.010619695 1 0.010619705 0 0.0106315416667 0 0.0106315516667 1 0.010639695 1
+ 0.010639705 0 0.0106515416667 0 0.0106515516667 1 0.010659695 1 0.010659705 0 0.0106715416667 0 0.0106715516667 1 0.010679695 1 0.010679705 0 0.0106915416667 0 0.0106915516667 1 0.010699695 1 0.010699705 0 0.0107115416667 0 0.0107115516667 1 0.010719695 1
+ 0.010719705 0 0.0107315416667 0 0.0107315516667 1 0.010739695 1 0.010739705 0 0.0107515416667 0 0.0107515516667 1 0.010759695 1 0.010759705 0 0.0107715416667 0 0.0107715516667 1 0.010779695 1 0.010779705 0 0.0107915416667 0 0.0107915516667 1 0.010799695 1
+ 0.010799705 0 0.0108115416667 0 0.0108115516667 1 0.010819695 1 0.010819705 0 0.0108315416667 0 0.0108315516667 1 0.010839695 1 0.010839705 0 0.0108515416667 0 0.0108515516667 1 0.010859695 1 0.010859705 0 0.0108715416667 0 0.0108715516667 1 0.010879695 1
+ 0.010879705 0 0.0108915416667 0 0.0108915516667 1 0.010899695 1 0.010899705 0 0.0109115416667 0 0.0109115516667 1 0.010919695 1 0.010919705 0 0.0109315416667 0 0.0109315516667 1 0.010939695 1 0.010939705 0 0.0109515416667 0 0.0109515516667 1 0.010959695 1
+ 0.010959705 0 0.0109715416667 0 0.0109715516667 1 0.010979695 1 0.010979705 0 0.0109915416667 0 0.0109915516667 1 0.010999695 1 0.010999705 0 0.0110115416667 0 0.0110115516667 1 0.011019695 1 0.011019705 0 0.0110315416667 0 0.0110315516667 1 0.011039695 1
+ 0.011039705 0 0.0110515416667 0 0.0110515516667 1 0.011059695 1 0.011059705 0 0.0110715416667 0 0.0110715516667 1 0.011079695 1 0.011079705 0 0.0110915416667 0 0.0110915516667 1 0.011099695 1 0.011099705 0 0.0111115416667 0 0.0111115516667 1 0.011119695 1
+ 0.011119705 0 0.0111315416667 0 0.0111315516667 1 0.011139695 1 0.011139705 0 0.0111515416667 0 0.0111515516667 1 0.011159695 1 0.011159705 0 0.0111715416667 0 0.0111715516667 1 0.011179695 1 0.011179705 0 0.0111915416667 0 0.0111915516667 1 0.011199695 1
+ 0.011199705 0 0.0112115416667 0 0.0112115516667 1 0.011219695 1 0.011219705 0 0.0112315416667 0 0.0112315516667 1 0.011239695 1 0.011239705 0 0.0112515416667 0 0.0112515516667 1 0.011259695 1 0.011259705 0 0.0112715416667 0 0.0112715516667 1 0.011279695 1
+ 0.011279705 0 0.0112915416667 0 0.0112915516667 1 0.011299695 1 0.011299705 0 0.0113115416667 0 0.0113115516667 1 0.011319695 1 0.011319705 0 0.0113315416667 0 0.0113315516667 1 0.011339695 1 0.011339705 0 0.0113515416667 0 0.0113515516667 1 0.011359695 1
+ 0.011359705 0 0.0113715416667 0 0.0113715516667 1 0.011379695 1 0.011379705 0 0.0113915416667 0 0.0113915516667 1 0.011399695 1 0.011399705 0 0.0114115416667 0 0.0114115516667 1 0.011419695 1 0.011419705 0 0.0114315416667 0 0.0114315516667 1 0.011439695 1
+ 0.011439705 0 0.0114515416667 0 0.0114515516667 1 0.011459695 1 0.011459705 0 0.0114715416667 0 0.0114715516667 1 0.011479695 1 0.011479705 0 0.0114915416667 0 0.0114915516667 1 0.011499695 1 0.011499705 0 0.0115115416667 0 0.0115115516667 1 0.011519695 1
+ 0.011519705 0 0.0115315416667 0 0.0115315516667 1 0.011539695 1 0.011539705 0 0.0115515416667 0 0.0115515516667 1 0.011559695 1 0.011559705 0 0.0115715416667 0 0.0115715516667 1 0.011579695 1 0.011579705 0 0.0115915416667 0 0.0115915516667 1 0.011599695 1
+ 0.011599705 0 0.0116115416667 0 0.0116115516667 1 0.011619695 1 0.011619705 0 0.0116315416667 0 0.0116315516667 1 0.011639695 1 0.011639705 0 0.0116515416667 0 0.0116515516667 1 0.011659695 1 0.011659705 0 0.0116715416667 0 0.0116715516667 1 0.011679695 1
+ 0.011679705 0 0.0116915416667 0 0.0116915516667 1 0.011699695 1 0.011699705 0 0.0117115416667 0 0.0117115516667 1 0.011719695 1 0.011719705 0 0.0117315416667 0 0.0117315516667 1 0.011739695 1 0.011739705 0 0.0117515416667 0 0.0117515516667 1 0.011759695 1
+ 0.011759705 0 0.0117715416667 0 0.0117715516667 1 0.011779695 1 0.011779705 0 0.0117915416667 0 0.0117915516667 1 0.011799695 1 0.011799705 0 0.0118115416667 0 0.0118115516667 1 0.011819695 1 0.011819705 0 0.0118315416667 0 0.0118315516667 1 0.011839695 1
+ 0.011839705 0 0.0118515416667 0 0.0118515516667 1 0.011859695 1 0.011859705 0 0.0118715416667 0 0.0118715516667 1 0.011879695 1 0.011879705 0 0.0118915416667 0 0.0118915516667 1 0.011899695 1 0.011899705 0 0.0119115416667 0 0.0119115516667 1 0.011919695 1
+ 0.011919705 0 0.0119315416667 0 0.0119315516667 1 0.011939695 1 0.011939705 0 0.0119515416667 0 0.0119515516667 1 0.011959695 1 0.011959705 0 0.0119715416667 0 0.0119715516667 1 0.011979695 1 0.011979705 0 0.0119915416667 0 0.0119915516667 1 0.011999695 1
+ 0.011999705 0 0.0120115416667 0 0.0120115516667 1 0.012019695 1 0.012019705 0 0.0120315416667 0 0.0120315516667 1 0.012039695 1 0.012039705 0 0.0120515416667 0 0.0120515516667 1 0.012059695 1 0.012059705 0 0.0120715416667 0 0.0120715516667 1 0.012079695 1
+ 0.012079705 0 0.0120915416667 0 0.0120915516667 1 0.012099695 1 0.012099705 0 0.0121115416667 0 0.0121115516667 1 0.012119695 1 0.012119705 0 0.0121315416667 0 0.0121315516667 1 0.012139695 1 0.012139705 0 0.0121515416667 0 0.0121515516667 1 0.012159695 1
+ 0.012159705 0 0.0121715416667 0 0.0121715516667 1 0.012179695 1 0.012179705 0 0.0121915416667 0 0.0121915516667 1 0.012199695 1 0.012199705 0 0.0122115416667 0 0.0122115516667 1 0.012219695 1 0.012219705 0 0.0122315416667 0 0.0122315516667 1 0.012239695 1
+ 0.012239705 0 0.0122515416667 0 0.0122515516667 1 0.012259695 1 0.012259705 0 0.0122715416667 0 0.0122715516667 1 0.012279695 1 0.012279705 0 0.0122915416667 0 0.0122915516667 1 0.012299695 1 0.012299705 0 0.0123115416667 0 0.0123115516667 1 0.012319695 1
+ 0.012319705 0 0.0123315416667 0 0.0123315516667 1 0.012339695 1 0.012339705 0 0.0123515416667 0 0.0123515516667 1 0.012359695 1 0.012359705 0 0.0123715416667 0 0.0123715516667 1 0.012379695 1 0.012379705 0 0.0123915416667 0 0.0123915516667 1 0.012399695 1
+ 0.012399705 0 0.0124115416667 0 0.0124115516667 1 0.012419695 1 0.012419705 0 0.0124315416667 0 0.0124315516667 1 0.012439695 1 0.012439705 0 0.0124515416667 0 0.0124515516667 1 0.012459695 1 0.012459705 0 0.0124715416667 0 0.0124715516667 1 0.012479695 1
+ 0.012479705 0 0.0124915416667 0 0.0124915516667 1 0.012499695 1 0.012499705 0 0.0125115416667 0 0.0125115516667 1 0.012519695 1 0.012519705 0 0.0125315416667 0 0.0125315516667 1 0.012539695 1 0.012539705 0 0.0125515416667 0 0.0125515516667 1 0.012559695 1
+ 0.012559705 0 0.0125715416667 0 0.0125715516667 1 0.012579695 1 0.012579705 0 0.0125915416667 0 0.0125915516667 1 0.012599695 1 0.012599705 0 0.0126115416667 0 0.0126115516667 1 0.012619695 1 0.012619705 0 0.0126315416667 0 0.0126315516667 1 0.012639695 1
+ 0.012639705 0 0.0126515416667 0 0.0126515516667 1 0.012659695 1 0.012659705 0 0.0126715416667 0 0.0126715516667 1 0.012679695 1 0.012679705 0 0.0126915416667 0 0.0126915516667 1 0.012699695 1 0.012699705 0 0.0127115416667 0 0.0127115516667 1 0.012719695 1
+ 0.012719705 0 0.0127315416667 0 0.0127315516667 1 0.012739695 1 0.012739705 0 0.0127515416667 0 0.0127515516667 1 0.012759695 1 0.012759705 0 0.0127715416667 0 0.0127715516667 1 0.012779695 1 0.012779705 0 0.0127915416667 0 0.0127915516667 1 0.012799695 1
+ 0.012799705 0 0.0128115416667 0 0.0128115516667 1 0.012819695 1 0.012819705 0 0.0128315416667 0 0.0128315516667 1 0.012839695 1 0.012839705 0 0.0128515416667 0 0.0128515516667 1 0.012859695 1 0.012859705 0 0.0128715416667 0 0.0128715516667 1 0.012879695 1
+ 0.012879705 0 0.0128915416667 0 0.0128915516667 1 0.012899695 1 0.012899705 0 0.0129115416667 0 0.0129115516667 1 0.012919695 1 0.012919705 0 0.0129315416667 0 0.0129315516667 1 0.012939695 1 0.012939705 0 0.0129515416667 0 0.0129515516667 1 0.012959695 1
+ 0.012959705 0 0.0129715416667 0 0.0129715516667 1 0.012979695 1 0.012979705 0 0.0129915416667 0 0.0129915516667 1 0.012999695 1 0.012999705 0 0.0130115416667 0 0.0130115516667 1 0.013019695 1 0.013019705 0 0.0130315416667 0 0.0130315516667 1 0.013039695 1
+ 0.013039705 0 0.0130515416667 0 0.0130515516667 1 0.013059695 1 0.013059705 0 0.0130715416667 0 0.0130715516667 1 0.013079695 1 0.013079705 0 0.0130915416667 0 0.0130915516667 1 0.013099695 1 0.013099705 0 0.0131115416667 0 0.0131115516667 1 0.013119695 1
+ 0.013119705 0 0.0131315416667 0 0.0131315516667 1 0.013139695 1 0.013139705 0 0.0131515416667 0 0.0131515516667 1 0.013159695 1 0.013159705 0 0.0131715416667 0 0.0131715516667 1 0.013179695 1 0.013179705 0 0.0131915416667 0 0.0131915516667 1 0.013199695 1
+ 0.013199705 0 0.0132115416667 0 0.0132115516667 1 0.013219695 1 0.013219705 0 0.0132315416667 0 0.0132315516667 1 0.013239695 1 0.013239705 0 0.0132515416667 0 0.0132515516667 1 0.013259695 1 0.013259705 0 0.0132715416667 0 0.0132715516667 1 0.013279695 1
+ 0.013279705 0 0.0132915416667 0 0.0132915516667 1 0.013299695 1 0.013299705 0 0.0133115416667 0 0.0133115516667 1 0.013319695 1 0.013319705 0 0.0133315416667 0 0.0133315516667 1 0.013339695 1 0.013339705 0 0.0133515416667 0 0.0133515516667 1 0.013359695 1
+ 0.013359705 0 0.0133715416667 0 0.0133715516667 1 0.013379695 1 0.013379705 0 0.0133915416667 0 0.0133915516667 1 0.013399695 1 0.013399705 0 0.0134115416667 0 0.0134115516667 1 0.013419695 1 0.013419705 0 0.0134315416667 0 0.0134315516667 1 0.013439695 1
+ 0.013439705 0 0.0134515416667 0 0.0134515516667 1 0.013459695 1 0.013459705 0 0.0134715416667 0 0.0134715516667 1 0.013479695 1 0.013479705 0 0.0134915416667 0 0.0134915516667 1 0.013499695 1 0.013499705 0 0.0135115416667 0 0.0135115516667 1 0.013519695 1
+ 0.013519705 0 0.0135315416667 0 0.0135315516667 1 0.013539695 1 0.013539705 0 0.0135515416667 0 0.0135515516667 1 0.013559695 1 0.013559705 0 0.0135715416667 0 0.0135715516667 1 0.013579695 1 0.013579705 0 0.0135915416667 0 0.0135915516667 1 0.013599695 1
+ 0.013599705 0 0.0136115416667 0 0.0136115516667 1 0.013619695 1 0.013619705 0 0.0136315416667 0 0.0136315516667 1 0.013639695 1 0.013639705 0 0.0136515416667 0 0.0136515516667 1 0.013659695 1 0.013659705 0 0.0136715416667 0 0.0136715516667 1 0.013679695 1
+ 0.013679705 0 0.0136915416667 0 0.0136915516667 1 0.013699695 1 0.013699705 0 0.0137115416667 0 0.0137115516667 1 0.013719695 1 0.013719705 0 0.0137315416667 0 0.0137315516667 1 0.013739695 1 0.013739705 0 0.0137515416667 0 0.0137515516667 1 0.013759695 1
+ 0.013759705 0 0.0137715416667 0 0.0137715516667 1 0.013779695 1 0.013779705 0 0.0137915416667 0 0.0137915516667 1 0.013799695 1 0.013799705 0 0.0138115416667 0 0.0138115516667 1 0.013819695 1 0.013819705 0 0.0138315416667 0 0.0138315516667 1 0.013839695 1
+ 0.013839705 0 0.0138515416667 0 0.0138515516667 1 0.013859695 1 0.013859705 0 0.0138715416667 0 0.0138715516667 1 0.013879695 1 0.013879705 0 0.0138915416667 0 0.0138915516667 1 0.013899695 1 0.013899705 0 0.0139115416667 0 0.0139115516667 1 0.013919695 1
+ 0.013919705 0 0.0139315416667 0 0.0139315516667 1 0.013939695 1 0.013939705 0 0.0139515416667 0 0.0139515516667 1 0.013959695 1 0.013959705 0 0.0139715416667 0 0.0139715516667 1 0.013979695 1 0.013979705 0 0.0139915416667 0 0.0139915516667 1 0.013999695 1
+ 0.013999705 0 0.0140115416667 0 0.0140115516667 1 0.014019695 1 0.014019705 0 0.0140315416667 0 0.0140315516667 1 0.014039695 1 0.014039705 0 0.0140515416667 0 0.0140515516667 1 0.014059695 1 0.014059705 0 0.0140715416667 0 0.0140715516667 1 0.014079695 1
+ 0.014079705 0 0.0140915416667 0 0.0140915516667 1 0.014099695 1 0.014099705 0 0.0141115416667 0 0.0141115516667 1 0.014119695 1 0.014119705 0 0.0141315416667 0 0.0141315516667 1 0.014139695 1 0.014139705 0 0.0141515416667 0 0.0141515516667 1 0.014159695 1
+ 0.014159705 0 0.0141715416667 0 0.0141715516667 1 0.014179695 1 0.014179705 0 0.0141915416667 0 0.0141915516667 1 0.014199695 1 0.014199705 0 0.0142115416667 0 0.0142115516667 1 0.014219695 1 0.014219705 0 0.0142315416667 0 0.0142315516667 1 0.014239695 1
+ 0.014239705 0 0.0142515416667 0 0.0142515516667 1 0.014259695 1 0.014259705 0 0.0142715416667 0 0.0142715516667 1 0.014279695 1 0.014279705 0 0.0142915416667 0 0.0142915516667 1 0.014299695 1 0.014299705 0 0.0143115416667 0 0.0143115516667 1 0.014319695 1
+ 0.014319705 0 0.0143315416667 0 0.0143315516667 1 0.014339695 1 0.014339705 0 0.0143515416667 0 0.0143515516667 1 0.014359695 1 0.014359705 0 0.0143715416667 0 0.0143715516667 1 0.014379695 1 0.014379705 0 0.0143915416667 0 0.0143915516667 1 0.014399695 1
+ 0.014399705 0 0.0144115416667 0 0.0144115516667 1 0.014419695 1 0.014419705 0 0.0144315416667 0 0.0144315516667 1 0.014439695 1 0.014439705 0 0.0144515416667 0 0.0144515516667 1 0.014459695 1 0.014459705 0 0.0144715416667 0 0.0144715516667 1 0.014479695 1
+ 0.014479705 0 0.0144915416667 0 0.0144915516667 1 0.014499695 1 0.014499705 0 0.0145115416667 0 0.0145115516667 1 0.014519695 1 0.014519705 0 0.0145315416667 0 0.0145315516667 1 0.014539695 1 0.014539705 0 0.0145515416667 0 0.0145515516667 1 0.014559695 1
+ 0.014559705 0 0.0145715416667 0 0.0145715516667 1 0.014579695 1 0.014579705 0 0.0145915416667 0 0.0145915516667 1 0.014599695 1 0.014599705 0 0.0146115416667 0 0.0146115516667 1 0.014619695 1 0.014619705 0 0.0146315416667 0 0.0146315516667 1 0.014639695 1
+ 0.014639705 0 0.0146515416667 0 0.0146515516667 1 0.014659695 1 0.014659705 0 0.0146715416667 0 0.0146715516667 1 0.014679695 1 0.014679705 0 0.0146915416667 0 0.0146915516667 1 0.014699695 1 0.014699705 0 0.0147115416667 0 0.0147115516667 1 0.014719695 1
+ 0.014719705 0 0.0147315416667 0 0.0147315516667 1 0.014739695 1 0.014739705 0 0.0147515416667 0 0.0147515516667 1 0.014759695 1 0.014759705 0 0.0147715416667 0 0.0147715516667 1 0.014779695 1 0.014779705 0 0.0147915416667 0 0.0147915516667 1 0.014799695 1
+ 0.014799705 0 0.0148115416667 0 0.0148115516667 1 0.014819695 1 0.014819705 0 0.0148315416667 0 0.0148315516667 1 0.014839695 1 0.014839705 0 0.0148515416667 0 0.0148515516667 1 0.014859695 1 0.014859705 0 0.0148715416667 0 0.0148715516667 1 0.014879695 1
+ 0.014879705 0 0.0148915416667 0 0.0148915516667 1 0.014899695 1 0.014899705 0 0.0149115416667 0 0.0149115516667 1 0.014919695 1 0.014919705 0 0.0149315416667 0 0.0149315516667 1 0.014939695 1 0.014939705 0 0.0149515416667 0 0.0149515516667 1 0.014959695 1
+ 0.014959705 0 0.0149715416667 0 0.0149715516667 1 0.014979695 1 0.014979705 0 0.0149915416667 0 0.0149915516667 1 0.014999695 1 0.014999705 0 0.0150115416667 0 0.0150115516667 1 0.015019695 1 0.015019705 0 0.0150315416667 0 0.0150315516667 1 0.015039695 1
+ 0.015039705 0 0.0150515416667 0 0.0150515516667 1 0.015059695 1 0.015059705 0 0.0150715416667 0 0.0150715516667 1 0.015079695 1 0.015079705 0 0.0150915416667 0 0.0150915516667 1 0.015099695 1 0.015099705 0 0.0151115416667 0 0.0151115516667 1 0.015119695 1
+ 0.015119705 0 0.0151315416667 0 0.0151315516667 1 0.015139695 1 0.015139705 0 0.0151515416667 0 0.0151515516667 1 0.015159695 1 0.015159705 0 0.0151715416667 0 0.0151715516667 1 0.015179695 1 0.015179705 0 0.0151915416667 0 0.0151915516667 1 0.015199695 1
+ 0.015199705 0 0.0152115416667 0 0.0152115516667 1 0.015219695 1 0.015219705 0 0.0152315416667 0 0.0152315516667 1 0.015239695 1 0.015239705 0 0.0152515416667 0 0.0152515516667 1 0.015259695 1 0.015259705 0 0.0152715416667 0 0.0152715516667 1 0.015279695 1
+ 0.015279705 0 0.0152915416667 0 0.0152915516667 1 0.015299695 1 0.015299705 0 0.0153115416667 0 0.0153115516667 1 0.015319695 1 0.015319705 0 0.0153315416667 0 0.0153315516667 1 0.015339695 1 0.015339705 0 0.0153515416667 0 0.0153515516667 1 0.015359695 1
+ 0.015359705 0 0.0153715416667 0 0.0153715516667 1 0.015379695 1 0.015379705 0 0.0153915416667 0 0.0153915516667 1 0.015399695 1 0.015399705 0 0.0154115416667 0 0.0154115516667 1 0.015419695 1 0.015419705 0 0.0154315416667 0 0.0154315516667 1 0.015439695 1
+ 0.015439705 0 0.0154515416667 0 0.0154515516667 1 0.015459695 1 0.015459705 0 0.0154715416667 0 0.0154715516667 1 0.015479695 1 0.015479705 0 0.0154915416667 0 0.0154915516667 1 0.015499695 1 0.015499705 0 0.0155115416667 0 0.0155115516667 1 0.015519695 1
+ 0.015519705 0 0.0155315416667 0 0.0155315516667 1 0.015539695 1 0.015539705 0 0.0155515416667 0 0.0155515516667 1 0.015559695 1 0.015559705 0 0.0155715416667 0 0.0155715516667 1 0.015579695 1 0.015579705 0 0.0155915416667 0 0.0155915516667 1 0.015599695 1
+ 0.015599705 0 0.0156115416667 0 0.0156115516667 1 0.015619695 1 0.015619705 0 0.0156315416667 0 0.0156315516667 1 0.015639695 1 0.015639705 0 0.0156515416667 0 0.0156515516667 1 0.015659695 1 0.015659705 0 0.0156715416667 0 0.0156715516667 1 0.015679695 1
+ 0.015679705 0 0.0156915416667 0 0.0156915516667 1 0.015699695 1 0.015699705 0 0.0157115416667 0 0.0157115516667 1 0.015719695 1 0.015719705 0 0.0157315416667 0 0.0157315516667 1 0.015739695 1 0.015739705 0 0.0157515416667 0 0.0157515516667 1 0.015759695 1
+ 0.015759705 0 0.0157715416667 0 0.0157715516667 1 0.015779695 1 0.015779705 0 0.0157915416667 0 0.0157915516667 1 0.015799695 1 0.015799705 0 0.0158115416667 0 0.0158115516667 1 0.015819695 1 0.015819705 0 0.0158315416667 0 0.0158315516667 1 0.015839695 1
+ 0.015839705 0 0.0158515416667 0 0.0158515516667 1 0.015859695 1 0.015859705 0 0.0158715416667 0 0.0158715516667 1 0.015879695 1 0.015879705 0 0.0158915416667 0 0.0158915516667 1 0.015899695 1 0.015899705 0 0.0159115416667 0 0.0159115516667 1 0.015919695 1
+ 0.015919705 0 0.0159315416667 0 0.0159315516667 1 0.015939695 1 0.015939705 0 0.0159515416667 0 0.0159515516667 1 0.015959695 1 0.015959705 0 0.0159715416667 0 0.0159715516667 1 0.015979695 1 0.015979705 0 0.0159915416667 0 0.0159915516667 1 0.015999695 1
+ 0.015999705 0 0.0160115416667 0 0.0160115516667 1 0.016019695 1 0.016019705 0 0.0160315416667 0 0.0160315516667 1 0.016039695 1 0.016039705 0 0.0160515416667 0 0.0160515516667 1 0.016059695 1 0.016059705 0 0.0160715416667 0 0.0160715516667 1 0.016079695 1
+ 0.016079705 0 0.0160915416667 0 0.0160915516667 1 0.016099695 1 0.016099705 0 0.0161115416667 0 0.0161115516667 1 0.016119695 1 0.016119705 0 0.0161315416667 0 0.0161315516667 1 0.016139695 1 0.016139705 0 0.0161515416667 0 0.0161515516667 1 0.016159695 1
+ 0.016159705 0 0.0161715416667 0 0.0161715516667 1 0.016179695 1 0.016179705 0 0.0161915416667 0 0.0161915516667 1 0.016199695 1 0.016199705 0 0.0162115416667 0 0.0162115516667 1 0.016219695 1 0.016219705 0 0.0162315416667 0 0.0162315516667 1 0.016239695 1
+ 0.016239705 0 0.0162515416667 0 0.0162515516667 1 0.016259695 1 0.016259705 0 0.0162715416667 0 0.0162715516667 1 0.016279695 1 0.016279705 0 0.0162915416667 0 0.0162915516667 1 0.016299695 1 0.016299705 0 0.0163115416667 0 0.0163115516667 1 0.016319695 1
+ 0.016319705 0 0.0163315416667 0 0.0163315516667 1 0.016339695 1 0.016339705 0 0.0163515416667 0 0.0163515516667 1 0.016359695 1 0.016359705 0 0.0163715416667 0 0.0163715516667 1 0.016379695 1 0.016379705 0 0.0163915416667 0 0.0163915516667 1 0.016399695 1
+ 0.016399705 0 0.0164115416667 0 0.0164115516667 1 0.016419695 1 0.016419705 0 0.0164315416667 0 0.0164315516667 1 0.016439695 1 0.016439705 0 0.0164515416667 0 0.0164515516667 1 0.016459695 1 0.016459705 0 0.0164715416667 0 0.0164715516667 1 0.016479695 1
+ 0.016479705 0 0.0164915416667 0 0.0164915516667 1 0.016499695 1 0.016499705 0 0.0165115416667 0 0.0165115516667 1 0.016519695 1 0.016519705 0 0.0165315416667 0 0.0165315516667 1 0.016539695 1 0.016539705 0 0.0165515416667 0 0.0165515516667 1 0.016559695 1
+ 0.016559705 0 0.0165715416667 0 0.0165715516667 1 0.016579695 1 0.016579705 0 0.0165915416667 0 0.0165915516667 1 0.016599695 1 0.016599705 0 0.0166115416667 0 0.0166115516667 1 0.016619695 1 0.016619705 0 0.0166315416667 0 0.0166315516667 1 0.016639695 1
+ 0.016639705 0 0.0166515416667 0 0.0166515516667 1 0.016659695 1 0.016659705 0 0.0166715416667 0 0.0166715516667 1 0.016679695 1 0.016679705 0 0.0166915416667 0 0.0166915516667 1 0.016699695 1 0.016699705 0 0.0167115416667 0 0.0167115516667 1 0.016719695 1
+ 0.016719705 0 0.0167315416667 0 0.0167315516667 1 0.016739695 1 0.016739705 0 0.0167515416667 0 0.0167515516667 1 0.016759695 1 0.016759705 0 0.0167715416667 0 0.0167715516667 1 0.016779695 1 0.016779705 0 0.0167915416667 0 0.0167915516667 1 0.016799695 1
+ 0.016799705 0 0.0168115416667 0 0.0168115516667 1 0.016819695 1 0.016819705 0 0.0168315416667 0 0.0168315516667 1 0.016839695 1 0.016839705 0 0.0168515416667 0 0.0168515516667 1 0.016859695 1 0.016859705 0 0.0168715416667 0 0.0168715516667 1 0.016879695 1
+ 0.016879705 0 0.0168915416667 0 0.0168915516667 1 0.016899695 1 0.016899705 0 0.0169115416667 0 0.0169115516667 1 0.016919695 1 0.016919705 0 0.0169315416667 0 0.0169315516667 1 0.016939695 1 0.016939705 0 0.0169515416667 0 0.0169515516667 1 0.016959695 1
+ 0.016959705 0 0.0169715416667 0 0.0169715516667 1 0.016979695 1 0.016979705 0 0.0169915416667 0 0.0169915516667 1 0.016999695 1 0.016999705 0 0.0170115416667 0 0.0170115516667 1 0.017019695 1 0.017019705 0 0.0170315416667 0 0.0170315516667 1 0.017039695 1
+ 0.017039705 0 0.0170515416667 0 0.0170515516667 1 0.017059695 1 0.017059705 0 0.0170715416667 0 0.0170715516667 1 0.017079695 1 0.017079705 0 0.0170915416667 0 0.0170915516667 1 0.017099695 1 0.017099705 0 0.0171115416667 0 0.0171115516667 1 0.017119695 1
+ 0.017119705 0 0.0171315416667 0 0.0171315516667 1 0.017139695 1 0.017139705 0 0.0171515416667 0 0.0171515516667 1 0.017159695 1 0.017159705 0 0.0171715416667 0 0.0171715516667 1 0.017179695 1 0.017179705 0 0.0171915416667 0 0.0171915516667 1 0.017199695 1
+ 0.017199705 0 0.0172115416667 0 0.0172115516667 1 0.017219695 1 0.017219705 0 0.0172315416667 0 0.0172315516667 1 0.017239695 1 0.017239705 0 0.0172515416667 0 0.0172515516667 1 0.017259695 1 0.017259705 0 0.0172715416667 0 0.0172715516667 1 0.017279695 1
+ 0.017279705 0 0.0172915416667 0 0.0172915516667 1 0.017299695 1 0.017299705 0 0.0173115416667 0 0.0173115516667 1 0.017319695 1 0.017319705 0 0.0173315416667 0 0.0173315516667 1 0.017339695 1 0.017339705 0 0.0173515416667 0 0.0173515516667 1 0.017359695 1
+ 0.017359705 0 0.0173715416667 0 0.0173715516667 1 0.017379695 1 0.017379705 0 0.0173915416667 0 0.0173915516667 1 0.017399695 1 0.017399705 0 0.0174115416667 0 0.0174115516667 1 0.017419695 1 0.017419705 0 0.0174315416667 0 0.0174315516667 1 0.017439695 1
+ 0.017439705 0 0.0174515416667 0 0.0174515516667 1 0.017459695 1 0.017459705 0 0.0174715416667 0 0.0174715516667 1 0.017479695 1 0.017479705 0 0.0174915416667 0 0.0174915516667 1 0.017499695 1 0.017499705 0 0.0175115416667 0 0.0175115516667 1 0.017519695 1
+ 0.017519705 0 0.0175315416667 0 0.0175315516667 1 0.017539695 1 0.017539705 0 0.0175515416667 0 0.0175515516667 1 0.017559695 1 0.017559705 0 0.0175715416667 0 0.0175715516667 1 0.017579695 1 0.017579705 0 0.0175915416667 0 0.0175915516667 1 0.017599695 1
+ 0.017599705 0 0.0176115416667 0 0.0176115516667 1 0.017619695 1 0.017619705 0 0.0176315416667 0 0.0176315516667 1 0.017639695 1 0.017639705 0 0.0176515416667 0 0.0176515516667 1 0.017659695 1 0.017659705 0 0.0176715416667 0 0.0176715516667 1 0.017679695 1
+ 0.017679705 0 0.0176915416667 0 0.0176915516667 1 0.017699695 1 0.017699705 0 0.0177115416667 0 0.0177115516667 1 0.017719695 1 0.017719705 0 0.0177315416667 0 0.0177315516667 1 0.017739695 1 0.017739705 0 0.0177515416667 0 0.0177515516667 1 0.017759695 1
+ 0.017759705 0 0.0177715416667 0 0.0177715516667 1 0.017779695 1 0.017779705 0 0.0177915416667 0 0.0177915516667 1 0.017799695 1 0.017799705 0 0.0178115416667 0 0.0178115516667 1 0.017819695 1 0.017819705 0 0.0178315416667 0 0.0178315516667 1 0.017839695 1
+ 0.017839705 0 0.0178515416667 0 0.0178515516667 1 0.017859695 1 0.017859705 0 0.0178715416667 0 0.0178715516667 1 0.017879695 1 0.017879705 0 0.0178915416667 0 0.0178915516667 1 0.017899695 1 0.017899705 0 0.0179115416667 0 0.0179115516667 1 0.017919695 1
+ 0.017919705 0 0.0179315416667 0 0.0179315516667 1 0.017939695 1 0.017939705 0 0.0179515416667 0 0.0179515516667 1 0.017959695 1 0.017959705 0 0.0179715416667 0 0.0179715516667 1 0.017979695 1 0.017979705 0 0.0179915416667 0 0.0179915516667 1 0.017999695 1
+ 0.017999705 0 0.0180115416667 0 0.0180115516667 1 0.018019695 1 0.018019705 0 0.0180315416667 0 0.0180315516667 1 0.018039695 1 0.018039705 0 0.0180515416667 0 0.0180515516667 1 0.018059695 1 0.018059705 0 0.0180715416667 0 0.0180715516667 1 0.018079695 1
+ 0.018079705 0 0.0180915416667 0 0.0180915516667 1 0.018099695 1 0.018099705 0 0.0181115416667 0 0.0181115516667 1 0.018119695 1 0.018119705 0 0.0181315416667 0 0.0181315516667 1 0.018139695 1 0.018139705 0 0.0181515416667 0 0.0181515516667 1 0.018159695 1
+ 0.018159705 0 0.0181715416667 0 0.0181715516667 1 0.018179695 1 0.018179705 0 0.0181915416667 0 0.0181915516667 1 0.018199695 1 0.018199705 0 0.0182115416667 0 0.0182115516667 1 0.018219695 1 0.018219705 0 0.0182315416667 0 0.0182315516667 1 0.018239695 1
+ 0.018239705 0 0.0182515416667 0 0.0182515516667 1 0.018259695 1 0.018259705 0 0.0182715416667 0 0.0182715516667 1 0.018279695 1 0.018279705 0 0.0182915416667 0 0.0182915516667 1 0.018299695 1 0.018299705 0 0.0183115416667 0 0.0183115516667 1 0.018319695 1
+ 0.018319705 0 0.0183315416667 0 0.0183315516667 1 0.018339695 1 0.018339705 0 0.0183515416667 0 0.0183515516667 1 0.018359695 1 0.018359705 0 0.0183715416667 0 0.0183715516667 1 0.018379695 1 0.018379705 0 0.0183915416667 0 0.0183915516667 1 0.018399695 1
+ 0.018399705 0 0.0184115416667 0 0.0184115516667 1 0.018419695 1 0.018419705 0 0.0184315416667 0 0.0184315516667 1 0.018439695 1 0.018439705 0 0.0184515416667 0 0.0184515516667 1 0.018459695 1 0.018459705 0 0.0184715416667 0 0.0184715516667 1 0.018479695 1
+ 0.018479705 0 0.0184915416667 0 0.0184915516667 1 0.018499695 1 0.018499705 0 0.0185115416667 0 0.0185115516667 1 0.018519695 1 0.018519705 0 0.0185315416667 0 0.0185315516667 1 0.018539695 1 0.018539705 0 0.0185515416667 0 0.0185515516667 1 0.018559695 1
+ 0.018559705 0 0.0185715416667 0 0.0185715516667 1 0.018579695 1 0.018579705 0 0.0185915416667 0 0.0185915516667 1 0.018599695 1 0.018599705 0 0.0186115416667 0 0.0186115516667 1 0.018619695 1 0.018619705 0 0.0186315416667 0 0.0186315516667 1 0.018639695 1
+ 0.018639705 0 0.0186515416667 0 0.0186515516667 1 0.018659695 1 0.018659705 0 0.0186715416667 0 0.0186715516667 1 0.018679695 1 0.018679705 0 0.0186915416667 0 0.0186915516667 1 0.018699695 1 0.018699705 0 0.0187115416667 0 0.0187115516667 1 0.018719695 1
+ 0.018719705 0 0.0187315416667 0 0.0187315516667 1 0.018739695 1 0.018739705 0 0.0187515416667 0 0.0187515516667 1 0.018759695 1 0.018759705 0 0.0187715416667 0 0.0187715516667 1 0.018779695 1 0.018779705 0 0.0187915416667 0 0.0187915516667 1 0.018799695 1
+ 0.018799705 0 0.0188115416667 0 0.0188115516667 1 0.018819695 1 0.018819705 0 0.0188315416667 0 0.0188315516667 1 0.018839695 1 0.018839705 0 0.0188515416667 0 0.0188515516667 1 0.018859695 1 0.018859705 0 0.0188715416667 0 0.0188715516667 1 0.018879695 1
+ 0.018879705 0 0.0188915416667 0 0.0188915516667 1 0.018899695 1 0.018899705 0 0.0189115416667 0 0.0189115516667 1 0.018919695 1 0.018919705 0 0.0189315416667 0 0.0189315516667 1 0.018939695 1 0.018939705 0 0.0189515416667 0 0.0189515516667 1 0.018959695 1
+ 0.018959705 0 0.0189715416667 0 0.0189715516667 1 0.018979695 1 0.018979705 0 0.0189915416667 0 0.0189915516667 1 0.018999695 1 0.018999705 0 0.0190115416667 0 0.0190115516667 1 0.019019695 1 0.019019705 0 0.0190315416667 0 0.0190315516667 1 0.019039695 1
+ 0.019039705 0 0.0190515416667 0 0.0190515516667 1 0.019059695 1 0.019059705 0 0.0190715416667 0 0.0190715516667 1 0.019079695 1 0.019079705 0 0.0190915416667 0 0.0190915516667 1 0.019099695 1 0.019099705 0 0.0191115416667 0 0.0191115516667 1 0.019119695 1
+ 0.019119705 0 0.0191315416667 0 0.0191315516667 1 0.019139695 1 0.019139705 0 0.0191515416667 0 0.0191515516667 1 0.019159695 1 0.019159705 0 0.0191715416667 0 0.0191715516667 1 0.019179695 1 0.019179705 0 0.0191915416667 0 0.0191915516667 1 0.019199695 1
+ 0.019199705 0 0.0192115416667 0 0.0192115516667 1 0.019219695 1 0.019219705 0 0.0192315416667 0 0.0192315516667 1 0.019239695 1 0.019239705 0 0.0192515416667 0 0.0192515516667 1 0.019259695 1 0.019259705 0 0.0192715416667 0 0.0192715516667 1 0.019279695 1
+ 0.019279705 0 0.0192915416667 0 0.0192915516667 1 0.019299695 1 0.019299705 0 0.0193115416667 0 0.0193115516667 1 0.019319695 1 0.019319705 0 0.0193315416667 0 0.0193315516667 1 0.019339695 1 0.019339705 0 0.0193515416667 0 0.0193515516667 1 0.019359695 1
+ 0.019359705 0 0.0193715416667 0 0.0193715516667 1 0.019379695 1 0.019379705 0 0.0193915416667 0 0.0193915516667 1 0.019399695 1 0.019399705 0 0.0194115416667 0 0.0194115516667 1 0.019419695 1 0.019419705 0 0.0194315416667 0 0.0194315516667 1 0.019439695 1
+ 0.019439705 0 0.0194515416667 0 0.0194515516667 1 0.019459695 1 0.019459705 0 0.0194715416667 0 0.0194715516667 1 0.019479695 1 0.019479705 0 0.0194915416667 0 0.0194915516667 1 0.019499695 1 0.019499705 0 0.0195115416667 0 0.0195115516667 1 0.019519695 1
+ 0.019519705 0 0.0195315416667 0 0.0195315516667 1 0.019539695 1 0.019539705 0 0.0195515416667 0 0.0195515516667 1 0.019559695 1 0.019559705 0 0.0195715416667 0 0.0195715516667 1 0.019579695 1 0.019579705 0 0.0195915416667 0 0.0195915516667 1 0.019599695 1
+ 0.019599705 0 0.0196115416667 0 0.0196115516667 1 0.019619695 1 0.019619705 0 0.0196315416667 0 0.0196315516667 1 0.019639695 1 0.019639705 0 0.0196515416667 0 0.0196515516667 1 0.019659695 1 0.019659705 0 0.0196715416667 0 0.0196715516667 1 0.019679695 1
+ 0.019679705 0 0.0196915416667 0 0.0196915516667 1 0.019699695 1 0.019699705 0 0.0197115416667 0 0.0197115516667 1 0.019719695 1 0.019719705 0 0.0197315416667 0 0.0197315516667 1 0.019739695 1 0.019739705 0 0.0197515416667 0 0.0197515516667 1 0.019759695 1
+ 0.019759705 0 0.0197715416667 0 0.0197715516667 1 0.019779695 1 0.019779705 0 0.0197915416667 0 0.0197915516667 1 0.019799695 1 0.019799705 0 0.0198115416667 0 0.0198115516667 1 0.019819695 1 0.019819705 0 0.0198315416667 0 0.0198315516667 1 0.019839695 1
+ 0.019839705 0 0.0198515416667 0 0.0198515516667 1 0.019859695 1 0.019859705 0 0.0198715416667 0 0.0198715516667 1 0.019879695 1 0.019879705 0 0.0198915416667 0 0.0198915516667 1 0.019899695 1 0.019899705 0 0.0199115416667 0 0.0199115516667 1 0.019919695 1
+ 0.019919705 0 0.0199315416667 0 0.0199315516667 1 0.019939695 1 0.019939705 0 0.0199515416667 0 0.0199515516667 1 0.019959695 1 0.019959705 0 0.0199715416667 0 0.0199715516667 1 0.019979695 1 0.019979705 0 0.0199915416667 0 0.0199915516667 1 0.019999695 1
+ 0.019999705 0 0.0200115416667 0 0.0200115516667 1 0.020019695 1 0.020019705 0 0.0200315416667 0 0.0200315516667 1 0.020039695 1 0.020039705 0 0.0200515416667 0 0.0200515516667 1 0.020059695 1 0.020059705 0 0.0200715416667 0 0.0200715516667 1 0.020079695 1
+ 0.020079705 0 0.0200915416667 0 0.0200915516667 1 0.020099695 1 0.020099705 0 0.0201115416667 0 0.0201115516667 1 0.020119695 1 0.020119705 0 0.0201315416667 0 0.0201315516667 1 0.020139695 1 0.020139705 0 0.0201515416667 0 0.0201515516667 1 0.020159695 1
+ 0.020159705 0 0.0201715416667 0 0.0201715516667 1 0.020179695 1 0.020179705 0 0.0201915416667 0 0.0201915516667 1 0.020199695 1 0.020199705 0 0.0202115416667 0 0.0202115516667 1 0.020219695 1 0.020219705 0 0.0202315416667 0 0.0202315516667 1 0.020239695 1
+ 0.020239705 0 0.0202515416667 0 0.0202515516667 1 0.020259695 1 0.020259705 0 0.0202715416667 0 0.0202715516667 1 0.020279695 1 0.020279705 0 0.0202915416667 0 0.0202915516667 1 0.020299695 1 0.020299705 0 0.0203115416667 0 0.0203115516667 1 0.020319695 1
+ 0.020319705 0 0.0203315416667 0 0.0203315516667 1 0.020339695 1 0.020339705 0 0.0203515416667 0 0.0203515516667 1 0.020359695 1 0.020359705 0 0.0203715416667 0 0.0203715516667 1 0.020379695 1 0.020379705 0 0.0203915416667 0 0.0203915516667 1 0.020399695 1
+ 0.020399705 0 0.0204115416667 0 0.0204115516667 1 0.020419695 1 0.020419705 0 0.0204315416667 0 0.0204315516667 1 0.020439695 1 0.020439705 0 0.0204515416667 0 0.0204515516667 1 0.020459695 1 0.020459705 0 0.0204715416667 0 0.0204715516667 1 0.020479695 1
+ 0.020479705 0 0.0204915416667 0 0.0204915516667 1 0.020499695 1 0.020499705 0 0.0205115416667 0 0.0205115516667 1 0.020519695 1 0.020519705 0 0.0205315416667 0 0.0205315516667 1 0.020539695 1 0.020539705 0 0.0205515416667 0 0.0205515516667 1 0.020559695 1
+ 0.020559705 0 0.0205715416667 0 0.0205715516667 1 0.020579695 1 0.020579705 0 0.0205915416667 0 0.0205915516667 1 0.020599695 1 0.020599705 0 0.0206115416667 0 0.0206115516667 1 0.020619695 1 0.020619705 0 0.0206315416667 0 0.0206315516667 1 0.020639695 1
+ 0.020639705 0 0.0206515416667 0 0.0206515516667 1 0.020659695 1 0.020659705 0 0.0206715416667 0 0.0206715516667 1 0.020679695 1 0.020679705 0 0.0206915416667 0 0.0206915516667 1 0.020699695 1 0.020699705 0 0.0207115416667 0 0.0207115516667 1 0.020719695 1
+ 0.020719705 0 0.0207315416667 0 0.0207315516667 1 0.020739695 1 0.020739705 0 0.0207515416667 0 0.0207515516667 1 0.020759695 1 0.020759705 0 0.0207715416667 0 0.0207715516667 1 0.020779695 1 0.020779705 0 0.0207915416667 0 0.0207915516667 1 0.020799695 1
+ 0.020799705 0 0.0208115416667 0 0.0208115516667 1 0.020819695 1 0.020819705 0 0.0208315416667 0 0.0208315516667 1 0.020839695 1 0.020839705 0 0.0208515416667 0 0.0208515516667 1 0.020859695 1 0.020859705 0 0.0208715416667 0 0.0208715516667 1 0.020879695 1
+ 0.020879705 0 0.0208915416667 0 0.0208915516667 1 0.020899695 1 0.020899705 0 0.0209115416667 0 0.0209115516667 1 0.020919695 1 0.020919705 0 0.0209315416667 0 0.0209315516667 1 0.020939695 1 0.020939705 0 0.0209515416667 0 0.0209515516667 1 0.020959695 1
+ 0.020959705 0 0.0209715416667 0 0.0209715516667 1 0.020979695 1 0.020979705 0 0.0209915416667 0 0.0209915516667 1 0.020999695 1 0.020999705 0 0.0210115416667 0 0.0210115516667 1 0.021019695 1 0.021019705 0 0.0210315416667 0 0.0210315516667 1 0.021039695 1
+ 0.021039705 0 0.0210515416667 0 0.0210515516667 1 0.021059695 1 0.021059705 0 0.0210715416667 0 0.0210715516667 1 0.021079695 1 0.021079705 0 0.0210915416667 0 0.0210915516667 1 0.021099695 1 0.021099705 0 0.0211115416667 0 0.0211115516667 1 0.021119695 1
+ 0.021119705 0 0.0211315416667 0 0.0211315516667 1 0.021139695 1 0.021139705 0 0.0211515416667 0 0.0211515516667 1 0.021159695 1 0.021159705 0 0.0211715416667 0 0.0211715516667 1 0.021179695 1 0.021179705 0 0.0211915416667 0 0.0211915516667 1 0.021199695 1
+ 0.021199705 0 0.0212115416667 0 0.0212115516667 1 0.021219695 1 0.021219705 0 0.0212315416667 0 0.0212315516667 1 0.021239695 1 0.021239705 0 0.0212515416667 0 0.0212515516667 1 0.021259695 1 0.021259705 0 0.0212715416667 0 0.0212715516667 1 0.021279695 1
+ 0.021279705 0 0.0212915416667 0 0.0212915516667 1 0.021299695 1 0.021299705 0 0.0213115416667 0 0.0213115516667 1 0.021319695 1 0.021319705 0 0.0213315416667 0 0.0213315516667 1 0.021339695 1 0.021339705 0 0.0213515416667 0 0.0213515516667 1 0.021359695 1
+ 0.021359705 0 0.0213715416667 0 0.0213715516667 1 0.021379695 1 0.021379705 0 0.0213915416667 0 0.0213915516667 1 0.021399695 1 0.021399705 0 0.0214115416667 0 0.0214115516667 1 0.021419695 1 0.021419705 0 0.0214315416667 0 0.0214315516667 1 0.021439695 1
+ 0.021439705 0 0.0214515416667 0 0.0214515516667 1 0.021459695 1 0.021459705 0 0.0214715416667 0 0.0214715516667 1 0.021479695 1 0.021479705 0 0.0214915416667 0 0.0214915516667 1 0.021499695 1 0.021499705 0 0.0215115416667 0 0.0215115516667 1 0.021519695 1
+ 0.021519705 0 0.0215315416667 0 0.0215315516667 1 0.021539695 1 0.021539705 0 0.0215515416667 0 0.0215515516667 1 0.021559695 1 0.021559705 0 0.0215715416667 0 0.0215715516667 1 0.021579695 1 0.021579705 0 0.0215915416667 0 0.0215915516667 1 0.021599695 1
+ 0.021599705 0 0.0216115416667 0 0.0216115516667 1 0.021619695 1 0.021619705 0 0.0216315416667 0 0.0216315516667 1 0.021639695 1 0.021639705 0 0.0216515416667 0 0.0216515516667 1 0.021659695 1 0.021659705 0 0.0216715416667 0 0.0216715516667 1 0.021679695 1
+ 0.021679705 0 0.0216915416667 0 0.0216915516667 1 0.021699695 1 0.021699705 0 0.0217115416667 0 0.0217115516667 1 0.021719695 1 0.021719705 0 0.0217315416667 0 0.0217315516667 1 0.021739695 1 0.021739705 0 0.0217515416667 0 0.0217515516667 1 0.021759695 1
+ 0.021759705 0 0.0217715416667 0 0.0217715516667 1 0.021779695 1 0.021779705 0 0.0217915416667 0 0.0217915516667 1 0.021799695 1 0.021799705 0 0.0218115416667 0 0.0218115516667 1 0.021819695 1 0.021819705 0 0.0218315416667 0 0.0218315516667 1 0.021839695 1
+ 0.021839705 0 0.0218515416667 0 0.0218515516667 1 0.021859695 1 0.021859705 0 0.0218715416667 0 0.0218715516667 1 0.021879695 1 0.021879705 0 0.0218915416667 0 0.0218915516667 1 0.021899695 1 0.021899705 0 0.0219115416667 0 0.0219115516667 1 0.021919695 1
+ 0.021919705 0 0.0219315416667 0 0.0219315516667 1 0.021939695 1 0.021939705 0 0.0219515416667 0 0.0219515516667 1 0.021959695 1 0.021959705 0 0.0219715416667 0 0.0219715516667 1 0.021979695 1 0.021979705 0 0.0219915416667 0 0.0219915516667 1 0.021999695 1
+ 0.021999705 0 0.0220115416667 0 0.0220115516667 1 0.022019695 1 0.022019705 0 0.0220315416667 0 0.0220315516667 1 0.022039695 1 0.022039705 0 0.0220515416667 0 0.0220515516667 1 0.022059695 1 0.022059705 0 0.0220715416667 0 0.0220715516667 1 0.022079695 1
+ 0.022079705 0 0.0220915416667 0 0.0220915516667 1 0.022099695 1 0.022099705 0 0.0221115416667 0 0.0221115516667 1 0.022119695 1 0.022119705 0 0.0221315416667 0 0.0221315516667 1 0.022139695 1 0.022139705 0 0.0221515416667 0 0.0221515516667 1 0.022159695 1
+ 0.022159705 0 0.0221715416667 0 0.0221715516667 1 0.022179695 1 0.022179705 0 0.0221915416667 0 0.0221915516667 1 0.022199695 1 0.022199705 0 0.0222115416667 0 0.0222115516667 1 0.022219695 1 0.022219705 0 0.0222315416667 0 0.0222315516667 1 0.022239695 1
+ 0.022239705 0 0.0222515416667 0 0.0222515516667 1 0.022259695 1 0.022259705 0 0.0222715416667 0 0.0222715516667 1 0.022279695 1 0.022279705 0 0.0222915416667 0 0.0222915516667 1 0.022299695 1 0.022299705 0 0.0223115416667 0 0.0223115516667 1 0.022319695 1
+ 0.022319705 0 0.0223315416667 0 0.0223315516667 1 0.022339695 1 0.022339705 0 0.0223515416667 0 0.0223515516667 1 0.022359695 1 0.022359705 0 0.0223715416667 0 0.0223715516667 1 0.022379695 1 0.022379705 0 0.0223915416667 0 0.0223915516667 1 0.022399695 1
+ 0.022399705 0 0.0224115416667 0 0.0224115516667 1 0.022419695 1 0.022419705 0 0.0224315416667 0 0.0224315516667 1 0.022439695 1 0.022439705 0 0.0224515416667 0 0.0224515516667 1 0.022459695 1 0.022459705 0 0.0224715416667 0 0.0224715516667 1 0.022479695 1
+ 0.022479705 0 0.0224915416667 0 0.0224915516667 1 0.022499695 1 0.022499705 0 0.0225115416667 0 0.0225115516667 1 0.022519695 1 0.022519705 0 0.0225315416667 0 0.0225315516667 1 0.022539695 1 0.022539705 0 0.0225515416667 0 0.0225515516667 1 0.022559695 1
+ 0.022559705 0 0.0225715416667 0 0.0225715516667 1 0.022579695 1 0.022579705 0 0.0225915416667 0 0.0225915516667 1 0.022599695 1 0.022599705 0 0.0226115416667 0 0.0226115516667 1 0.022619695 1 0.022619705 0 0.0226315416667 0 0.0226315516667 1 0.022639695 1
+ 0.022639705 0 0.0226515416667 0 0.0226515516667 1 0.022659695 1 0.022659705 0 0.0226715416667 0 0.0226715516667 1 0.022679695 1 0.022679705 0 0.0226915416667 0 0.0226915516667 1 0.022699695 1 0.022699705 0 0.0227115416667 0 0.0227115516667 1 0.022719695 1
+ 0.022719705 0 0.0227315416667 0 0.0227315516667 1 0.022739695 1 0.022739705 0 0.0227515416667 0 0.0227515516667 1 0.022759695 1 0.022759705 0 0.0227715416667 0 0.0227715516667 1 0.022779695 1 0.022779705 0 0.0227915416667 0 0.0227915516667 1 0.022799695 1
+ 0.022799705 0 0.0228115416667 0 0.0228115516667 1 0.022819695 1 0.022819705 0 0.0228315416667 0 0.0228315516667 1 0.022839695 1 0.022839705 0 0.0228515416667 0 0.0228515516667 1 0.022859695 1 0.022859705 0 0.0228715416667 0 0.0228715516667 1 0.022879695 1
+ 0.022879705 0 0.0228915416667 0 0.0228915516667 1 0.022899695 1 0.022899705 0 0.0229115416667 0 0.0229115516667 1 0.022919695 1 0.022919705 0 0.0229315416667 0 0.0229315516667 1 0.022939695 1 0.022939705 0 0.0229515416667 0 0.0229515516667 1 0.022959695 1
+ 0.022959705 0 0.0229715416667 0 0.0229715516667 1 0.022979695 1 0.022979705 0 0.0229915416667 0 0.0229915516667 1 0.022999695 1 0.022999705 0 0.0230115416667 0 0.0230115516667 1 0.023019695 1 0.023019705 0 0.0230315416667 0 0.0230315516667 1 0.023039695 1
+ 0.023039705 0 0.0230515416667 0 0.0230515516667 1 0.023059695 1 0.023059705 0 0.0230715416667 0 0.0230715516667 1 0.023079695 1 0.023079705 0 0.0230915416667 0 0.0230915516667 1 0.023099695 1 0.023099705 0 0.0231115416667 0 0.0231115516667 1 0.023119695 1
+ 0.023119705 0 0.0231315416667 0 0.0231315516667 1 0.023139695 1 0.023139705 0 0.0231515416667 0 0.0231515516667 1 0.023159695 1 0.023159705 0 0.0231715416667 0 0.0231715516667 1 0.023179695 1 0.023179705 0 0.0231915416667 0 0.0231915516667 1 0.023199695 1
+ 0.023199705 0 0.0232115416667 0 0.0232115516667 1 0.023219695 1 0.023219705 0 0.0232315416667 0 0.0232315516667 1 0.023239695 1 0.023239705 0 0.0232515416667 0 0.0232515516667 1 0.023259695 1 0.023259705 0 0.0232715416667 0 0.0232715516667 1 0.023279695 1
+ 0.023279705 0 0.0232915416667 0 0.0232915516667 1 0.023299695 1 0.023299705 0 0.0233115416667 0 0.0233115516667 1 0.023319695 1 0.023319705 0 0.0233315416667 0 0.0233315516667 1 0.023339695 1 0.023339705 0 0.0233515416667 0 0.0233515516667 1 0.023359695 1
+ 0.023359705 0 0.0233715416667 0 0.0233715516667 1 0.023379695 1 0.023379705 0 0.0233915416667 0 0.0233915516667 1 0.023399695 1 0.023399705 0 0.0234115416667 0 0.0234115516667 1 0.023419695 1 0.023419705 0 0.0234315416667 0 0.0234315516667 1 0.023439695 1
+ 0.023439705 0 0.0234515416667 0 0.0234515516667 1 0.023459695 1 0.023459705 0 0.0234715416667 0 0.0234715516667 1 0.023479695 1 0.023479705 0 0.0234915416667 0 0.0234915516667 1 0.023499695 1 0.023499705 0 0.0235115416667 0 0.0235115516667 1 0.023519695 1
+ 0.023519705 0 0.0235315416667 0 0.0235315516667 1 0.023539695 1 0.023539705 0 0.0235515416667 0 0.0235515516667 1 0.023559695 1 0.023559705 0 0.0235715416667 0 0.0235715516667 1 0.023579695 1 0.023579705 0 0.0235915416667 0 0.0235915516667 1 0.023599695 1
+ 0.023599705 0 0.0236115416667 0 0.0236115516667 1 0.023619695 1 0.023619705 0 0.0236315416667 0 0.0236315516667 1 0.023639695 1 0.023639705 0 0.0236515416667 0 0.0236515516667 1 0.023659695 1 0.023659705 0 0.0236715416667 0 0.0236715516667 1 0.023679695 1
+ 0.023679705 0 0.0236915416667 0 0.0236915516667 1 0.023699695 1 0.023699705 0 0.0237115416667 0 0.0237115516667 1 0.023719695 1 0.023719705 0 0.0237315416667 0 0.0237315516667 1 0.023739695 1 0.023739705 0 0.0237515416667 0 0.0237515516667 1 0.023759695 1
+ 0.023759705 0 0.0237715416667 0 0.0237715516667 1 0.023779695 1 0.023779705 0 0.0237915416667 0 0.0237915516667 1 0.023799695 1 0.023799705 0 0.0238115416667 0 0.0238115516667 1 0.023819695 1 0.023819705 0 0.0238315416667 0 0.0238315516667 1 0.023839695 1
+ 0.023839705 0 0.0238515416667 0 0.0238515516667 1 0.023859695 1 0.023859705 0 0.0238715416667 0 0.0238715516667 1 0.023879695 1 0.023879705 0 0.0238915416667 0 0.0238915516667 1 0.023899695 1 0.023899705 0 0.0239115416667 0 0.0239115516667 1 0.023919695 1
+ 0.023919705 0 0.0239315416667 0 0.0239315516667 1 0.023939695 1 0.023939705 0 0.0239515416667 0 0.0239515516667 1 0.023959695 1 0.023959705 0 0.0239715416667 0 0.0239715516667 1 0.023979695 1 0.023979705 0 0.0239915416667 0 0.0239915516667 1 0.023999695 1
+ 0.023999705 0 0.0240115416667 0 0.0240115516667 1 0.024019695 1 0.024019705 0 0.0240315416667 0 0.0240315516667 1 0.024039695 1 0.024039705 0 0.0240515416667 0 0.0240515516667 1 0.024059695 1 0.024059705 0 0.0240715416667 0 0.0240715516667 1 0.024079695 1
+ 0.024079705 0 0.0240915416667 0 0.0240915516667 1 0.024099695 1 0.024099705 0 0.0241115416667 0 0.0241115516667 1 0.024119695 1 0.024119705 0 0.0241315416667 0 0.0241315516667 1 0.024139695 1 0.024139705 0 0.0241515416667 0 0.0241515516667 1 0.024159695 1
+ 0.024159705 0 0.0241715416667 0 0.0241715516667 1 0.024179695 1 0.024179705 0 0.0241915416667 0 0.0241915516667 1 0.024199695 1 0.024199705 0 0.0242115416667 0 0.0242115516667 1 0.024219695 1 0.024219705 0 0.0242315416667 0 0.0242315516667 1 0.024239695 1
+ 0.024239705 0 0.0242515416667 0 0.0242515516667 1 0.024259695 1 0.024259705 0 0.0242715416667 0 0.0242715516667 1 0.024279695 1 0.024279705 0 0.0242915416667 0 0.0242915516667 1 0.024299695 1 0.024299705 0 0.0243115416667 0 0.0243115516667 1 0.024319695 1
+ 0.024319705 0 0.0243315416667 0 0.0243315516667 1 0.024339695 1 0.024339705 0 0.0243515416667 0 0.0243515516667 1 0.024359695 1 0.024359705 0 0.0243715416667 0 0.0243715516667 1 0.024379695 1 0.024379705 0 0.0243915416667 0 0.0243915516667 1 0.024399695 1
+ 0.024399705 0 0.0244115416667 0 0.0244115516667 1 0.024419695 1 0.024419705 0 0.0244315416667 0 0.0244315516667 1 0.024439695 1 0.024439705 0 0.0244515416667 0 0.0244515516667 1 0.024459695 1 0.024459705 0 0.0244715416667 0 0.0244715516667 1 0.024479695 1
+ 0.024479705 0 0.0244915416667 0 0.0244915516667 1 0.024499695 1 0.024499705 0 0.0245115416667 0 0.0245115516667 1 0.024519695 1 0.024519705 0 0.0245315416667 0 0.0245315516667 1 0.024539695 1 0.024539705 0 0.0245515416667 0 0.0245515516667 1 0.024559695 1
+ 0.024559705 0 0.0245715416667 0 0.0245715516667 1 0.024579695 1 0.024579705 0 0.0245915416667 0 0.0245915516667 1 0.024599695 1 0.024599705 0 0.0246115416667 0 0.0246115516667 1 0.024619695 1 0.024619705 0 0.0246315416667 0 0.0246315516667 1 0.024639695 1
+ 0.024639705 0 0.0246515416667 0 0.0246515516667 1 0.024659695 1 0.024659705 0 0.0246715416667 0 0.0246715516667 1 0.024679695 1 0.024679705 0 0.0246915416667 0 0.0246915516667 1 0.024699695 1 0.024699705 0 0.0247115416667 0 0.0247115516667 1 0.024719695 1
+ 0.024719705 0 0.0247315416667 0 0.0247315516667 1 0.024739695 1 0.024739705 0 0.0247515416667 0 0.0247515516667 1 0.024759695 1 0.024759705 0 0.0247715416667 0 0.0247715516667 1 0.024779695 1 0.024779705 0 0.0247915416667 0 0.0247915516667 1 0.024799695 1
+ 0.024799705 0 0.0248115416667 0 0.0248115516667 1 0.024819695 1 0.024819705 0 0.0248315416667 0 0.0248315516667 1 0.024839695 1 0.024839705 0 0.0248515416667 0 0.0248515516667 1 0.024859695 1 0.024859705 0 0.0248715416667 0 0.0248715516667 1 0.024879695 1
+ 0.024879705 0 0.0248915416667 0 0.0248915516667 1 0.024899695 1 0.024899705 0 0.0249115416667 0 0.0249115516667 1 0.024919695 1 0.024919705 0 0.0249315416667 0 0.0249315516667 1 0.024939695 1 0.024939705 0 0.0249515416667 0 0.0249515516667 1 0.024959695 1
+ 0.024959705 0 0.0249715416667 0 0.0249715516667 1 0.024979695 1 0.024979705 0 0.0249915416667 0 0.0249915516667 1 0.024999695 1 0.024999705 0 0.0250115416667 0 0.0250115516667 1 0.025019695 1 0.025019705 0)
Rghs ghs 0 1Meg
Rgls gls 0 1Meg
.model SWHS SW(Ron=0.068244 Roff=1e6 Vt=0.5 Vh=0.1)
.model SWLS SW(Ron=0.068244 Roff=1e6 Vt=0.5 Vh=0.1)
.model DBODY D(Is=9.05298e-34 N=2 Rs=0.02)
.ic V(out)=0
.options method=gear reltol=0.001 abstol=1e-06 vntol=0.0001
.tran 1e-07 0.025
.end
